* Figura 50.7 (sección 50.5), cálculos de las secciones 50.5, 50.9 y 50.14 (punto 6) y ejercicio 50.2:
* rectificador en puente con condensador de filtro y carga de corriente constante.
* Cada caso es un circuito independiente (transformador = senoide de 50 Hz con 0,05 Ohm en serie;
* diodos de puente de varios amperios con los parámetros del 1N5408). Se mide entre 400 y 600 ms
* la media, el valle y el rizado pico a pico de la tensión del condensador.
*   A  sección 50.5: 18 V eficaces, 5000 uF, 1 A. Libro: 23,1 V de media con 2 V de rizado (fórmula).
*   A- la misma con la red al -10 % (16,2 V): libro 20,5 V.   A+ red +10 % (19,8 V) y en vacío: 26,6 V.
*   B  sección 50.9 corregida: 30 V eficaces, 10 000 uF, 3 A. Libro: 39,5 V nominales; 35,3 V con la
*      red al -10 % (valle 33,8 V); 45,3 V con la red al +10 % en vacío (antes de la regulación del
*      transformador, que lo lleva a unos 48 V).
*   B24 el diseño original con 24 V eficaces: valle de unos 29 V a 3 A con la red nominal, y unos
*      26 V con la red baja: con 2,5-4 V de caída en el regulador no puede dar 30 V a 3 A.
*   C  sección 50.14 (punto 6): 30 V eficaces, 5 A, 22 000 uF (libro: 2,27 V con la fórmula) y
*      10 000 uF (libro: 5,0 V). La simulación da algo menos (la fórmula sobrestima, sección 3.11).
*   D  ejercicio 50.2: 10 000 uF, 1 A, rizado de 1 V como máximo (12 V eficaces).
* Ejecutar: ngspice -b rectificador.cir
.model DPTE D(Is=63n Rs=10m N=1.7 Cjo=50p)

* The secondary floats: each bridge sits between the two AC nodes of its own source, and the
* DC side is referred to ground through 10 kOhm only to keep the matrix solvable.

* ---- case A: 18 V rms, 5000 uF, 1 A
VA aA bA SIN(0 {18*1.41421} 50)
RA aA a1A 0.05
DA1 a1A pA DPTE
DA2 bA pA DPTE
DA3 nA a1A DPTE
DA4 nA bA DPTE
CA pA nA 5000u
IA pA nA PWL(0 0 40m 0 80m 1)
RGA nA 0 10k
RHA bA 0 10k
* ---- case A-: 16.2 V rms, 1 A
VAm aAm bAm SIN(0 {16.2*1.41421} 50)
RAm aAm a1Am 0.05
DAm1 a1Am pAm DPTE
DAm2 bAm pAm DPTE
DAm3 nAm a1Am DPTE
DAm4 nAm bAm DPTE
CAm pAm nAm 5000u
IAm pAm nAm PWL(0 0 40m 0 80m 1)
RGAm nAm 0 10k
RHAm bAm 0 10k
* ---- case A+: 19.8 V rms, no load (1 mA)
VAp aAp bAp SIN(0 {19.8*1.41421} 50)
RAp aAp a1Ap 0.05
DAp1 a1Ap pAp DPTE
DAp2 bAp pAp DPTE
DAp3 nAp a1Ap DPTE
DAp4 nAp bAp DPTE
CAp pAp nAp 5000u
IAp pAp nAp PWL(0 0 40m 0 80m 1m)
RGAp nAp 0 10k
RHAp bAp 0 10k
* ---- case B: 30 V rms, 10 000 uF, 3 A
VB aB bB SIN(0 {30*1.41421} 50)
RB aB a1B 0.05
DB1 a1B pB DPTE
DB2 bB pB DPTE
DB3 nB a1B DPTE
DB4 nB bB DPTE
CB pB nB 10000u
IB pB nB PWL(0 0 40m 0 80m 3)
RGB nB 0 10k
RHB bB 0 10k
* ---- case B-: 27 V rms, 3 A
VBm aBm bBm SIN(0 {27*1.41421} 50)
RBm aBm a1Bm 0.05
DBm1 a1Bm pBm DPTE
DBm2 bBm pBm DPTE
DBm3 nBm a1Bm DPTE
DBm4 nBm bBm DPTE
CBm pBm nBm 10000u
IBm pBm nBm PWL(0 0 40m 0 80m 3)
RGBm nBm 0 10k
RHBm bBm 0 10k
* ---- case B+: 33 V rms, no load
VBp aBp bBp SIN(0 {33*1.41421} 50)
RBp aBp a1Bp 0.05
DBp1 a1Bp pBp DPTE
DBp2 bBp pBp DPTE
DBp3 nBp a1Bp DPTE
DBp4 nBp bBp DPTE
CBp pBp nBp 10000u
IBp pBp nBp PWL(0 0 40m 0 80m 1m)
RGBp nBp 0 10k
RHBp bBp 0 10k
* ---- case B24: original 24 V rms, 3 A (nominal) and 21.6 V rms (-10 %)
VQ aQ bQ SIN(0 {24*1.41421} 50)
RQ aQ a1Q 0.05
DQ1 a1Q pQ DPTE
DQ2 bQ pQ DPTE
DQ3 nQ a1Q DPTE
DQ4 nQ bQ DPTE
CQ pQ nQ 10000u
IQ pQ nQ PWL(0 0 40m 0 80m 3)
RGQ nQ 0 10k
RHQ bQ 0 10k
VQm aQm bQm SIN(0 {21.6*1.41421} 50)
RQm aQm a1Qm 0.05
DQm1 a1Qm pQm DPTE
DQm2 bQm pQm DPTE
DQm3 nQm a1Qm DPTE
DQm4 nQm bQm DPTE
CQm pQm nQm 10000u
IQm pQm nQm PWL(0 0 40m 0 80m 3)
RGQm nQm 0 10k
RHQm bQm 0 10k
* ---- case C: 30 V rms, 5 A, 22 000 uF and 10 000 uF
VC aC bC SIN(0 {30*1.41421} 50)
RC aC a1C 0.05
DC1 a1C pC DPTE
DC2 bC pC DPTE
DC3 nC a1C DPTE
DC4 nC bC DPTE
CC pC nC 22000u
IC pC nC PWL(0 0 40m 0 80m 5)
RGC nC 0 10k
RHC bC 0 10k
VK aK bK SIN(0 {30*1.41421} 50)
RK aK a1K 0.05
DK1 a1K pK DPTE
DK2 bK pK DPTE
DK3 nK a1K DPTE
DK4 nK bK DPTE
CK pK nK 10000u
IK pK nK PWL(0 0 40m 0 80m 5)
RGK nK 0 10k
RHK bK 0 10k
* ---- case D: exercise 50.2, 12 V rms, 10 000 uF, 1 A
VD aD bD SIN(0 {12*1.41421} 50)
RD aD a1D 0.05
DD1 a1D pD DPTE
DD2 bD pD DPTE
DD3 nD a1D DPTE
DD4 nD bD DPTE
CD pD nD 10000u
ID pD nD PWL(0 0 40m 0 80m 1)
RGD nD 0 10k
RHD bD 0 10k

* .options method=gear helps with the abrupt diode turn-on
.options method=gear
* loads ramp up between 40 and 80 ms, after the first charge of the capacitors
.tran 20u 600m 0 20u
.control
  run
  foreach k A Am Ap B Bm Bp Q Qm C K D
    let vv = v(p$k) - v(n$k)
    meas tran avg_$k avg vv from=400m to=600m
    meas tran max_$k max vv from=400m to=600m
    meas tran min_$k min vv from=400m to=600m
    let pp_$k = max_$k - min_$k
    echo "caso $k: media, maximo, valle, rizado pp (V):"
    print avg_$k max_$k min_$k pp_$k
  end
  echo "Formula C = I/(f dV): 1 A/(100 Hz x 5000 uF) = 2 V; 3 A/(100 x 10 mF) = 3 V;"
  echo "5 A/(100 x 22 mF) = 2,27 V; 5 A/(100 x 10 mF) = 5 V; 1 A/(100 x 10 mF) = 1 V"
.endc
.end
