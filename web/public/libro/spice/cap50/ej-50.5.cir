* Ejercicio 50.5 (sección 50.8): limitación de corriente con un transistor cuyo umbral V_BE es de
* unos 0,65 V. Regulador seguidor: Darlington de paso (Q1 + Q2) excitado por 4,7 kOhm desde 20 V, con
* la base fijada por un Zener de 12 V (salida de unos 10,8 V); R_sense = 0,33 Ohm en el emisor y un
* transistor pequeño (tipo BC547/2N3904) cuya base-emisor está en paralelo con R_sense y que roba la
* corriente de base cuando la caída alcanza su umbral. El libro: 0,65 V / 2 A = 0,325 Ohm -> 0,33 Ohm,
* que limita a unos 2 A, con 2^2 x 0,33 = 1,3 W en la resistencia.
* Comprueba: corriente en cortocircuito y con 2 Ohm de carga, y la potencia en R_sense.
* Ejecutar: ngspice -b ej-50.5.cir
.model QPOW NPN(Is=1e-12 Bf=40 Vaf=100 Ikf=5 Rb=1 Re=0.02 Rc=0.05)
.model QDRV NPN(Is=1e-13 Bf=120 Vaf=100 Ikf=1 Rb=5)
.model QSIG NPN(Is=6.7f Bf=200 Vaf=74 Ikf=66m Rb=10)
.model DZ12 D(Is=1e-14 N=1 Bv=12 Ibv=5m Rs=2)
VIN in 0 DC 20
RB in b 4.7k
DZ 0 b DZ12
Q2 in b m QDRV
Q1 in m e QPOW
RS e out 0.33
QL b e out QSIG
RL out 0 2
.control
  foreach r 10 5 2 0.01
    alter RL resistance = $r
    op
    echo "RL = $r Ohm: Vout, Iout, V(R_sense), P(R_sense)"
    print v(out) v(out)/$r v(e,out) v(e,out)*v(e,out)/0.33
  end
.endc
.end
