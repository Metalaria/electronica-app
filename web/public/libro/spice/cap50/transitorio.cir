* Sección 50.14, punto 7 (y punto 8 / lista de materiales): caída de la salida ante un escalón de carga
* de 5 A mientras el lazo tarda 50 us en reaccionar, Delta V = Delta I x t / C_out, y energía
* almacenada en C_out a 30 V (la que descarga sobre un cortocircuito o sobre el tiristor de crowbar).
* Libro: 2500 mV con 100 uF, 250 mV con 1000 uF; con los 470 uF de la lista de materiales, 532 mV.
* Energía: 450 mJ con 1000 uF y 211 mJ con 470 uF.
* Ejecutar: ngspice -b transitorio.cir
.param tr = 50u
C1 a 0 100u IC=30
I1 a 0 PULSE(0 5 0 1n 1n {tr} 1)
C2 b 0 1000u IC=30
I2 b 0 PULSE(0 5 0 1n 1n {tr} 1)
C3 c 0 470u IC=30
I3 c 0 PULSE(0 5 0 1n 1n {tr} 1)
.tran 0.1u 60u uic
.control
  run
  meas tran d100 find v(a) at=50u
  meas tran d1000 find v(b) at=50u
  meas tran d470 find v(c) at=50u
  print 30-d100 30-d1000 30-d470
  echo "energia a 30 V (J): 1000 uF y 470 uF"
  print 0.5*1000e-6*900 0.5*470e-6*900
.endc
.end
