* Sección 29.2 («En el banco»): una OR montada con tres de las cuatro NAND de un 74HC00, dos como
* inversores (entradas unidas) y una tercera que hace la NAND de las entradas negadas. Por De Morgan,
* NAND(A', B') = A + B. Puertas XSPICE con 8 ns de retardo (orden de un 74HC00 a 5 V).
* A y B recorren las combinaciones 00, 01, 10, 11, un microsegundo cada una.
* Comprueba la tabla de verdad: Y = 0, 1, 1, 1, igual que la OR de referencia.
* Ejecutar: ngspice -b sec-29.2-or-con-nand.cir
VA a 0 PWL(0 0 1.999u 0 2u 5 4u 5)
VB b 0 PWL(0 0 0.999u 0 1u 5 1.999u 5 2u 0 2.999u 0 3u 5 4u 5)
.model toDig adc_bridge(in_low=2.4 in_high=2.6 rise_delay=1p fall_delay=1p)
.model toAna dac_bridge(out_low=0 out_high=5 t_rise=1n t_fall=1n)
.model nand8 d_nand(rise_delay=8n fall_delay=8n)
.model or8 d_or(rise_delay=8n fall_delay=8n)
Aad [a b] [ad bd] toDig
* NAND 1 and 2: inverters
An1 [ad ad] na nand8
An2 [bd bd] nb nand8
* NAND 3: NAND of the inverted inputs
An3 [na nb] yd nand8
* reference OR
Aor [ad bd] ord or8
Ada [yd ord] [y yor] toAna
.tran 1n 4u
.control
  run
  echo "Filas AB = 00, 01, 10, 11 (instantes 0,5 / 1,5 / 2,5 / 3,5 us). Esperado Y = 0, 5, 5, 5 V."
  foreach tt 0.5u 1.5u 2.5u 3.5u
    meas tran y_$tt find v(y) at=$tt
    meas tran or_$tt find v(yor) at=$tt
  end
.endc
.end
