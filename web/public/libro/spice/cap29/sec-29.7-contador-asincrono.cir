* Sección 29.7 («Contadores asíncronos») y figura 29.11: contador asíncrono (de rizado) de 8 etapas
* con 10 ns de retardo por biestable. Cada biestable T (T = 1) se dispara con la salida negada del
* anterior, es decir, con el flanco de bajada de su Q: es un contador ascendente.
* Reloj de 200 ns de periodo, primer flanco de subida a 100 ns. Biestables XSPICE d_tff.
* Comprueba, en el flanco 128 (de 0111 1111 a 1000 0000, t = 25,5 us):
*   - el bit 0 cambia 10 ns después del flanco y el bit 7, 80 ns después: 70 ns entre ambos;
*   - durante esos 70 ns la salida recorre 126, 124, 120, 112, 96, 64 y 0 antes de llegar a 128,
*     de modo que un decodificador de la cuenta 0 (una NOR de 8 entradas) da un pulso falso de
*     10 ns, entre la caída del bit 6 (70 ns) y la subida del bit 7 (80 ns).
* Ejecutar: ngspice -b sec-29.7-contador-asincrono.cir
VCLK clk 0 PULSE(0 5 100n 0.01n 0.01n 99.99n 200n)
VONE one 0 DC 5
.model toDig adc_bridge(in_low=2.4 in_high=2.6 rise_delay=1p fall_delay=1p)
.model toAna dac_bridge(out_low=0 out_high=5 t_rise=0.01n t_fall=0.01n)
.model tff10 d_tff(clk_delay=10n set_delay=1n reset_delay=1n ic=0 rise_delay=1p fall_delay=1p)
.model nor8 d_nor(rise_delay=1p fall_delay=1p)
Aad [clk one] [clkd hi] toDig
A0 hi clkd NULL NULL q0 nq0 tff10
A1 hi nq0 NULL NULL q1 nq1 tff10
A2 hi nq1 NULL NULL q2 nq2 tff10
A3 hi nq2 NULL NULL q3 nq3 tff10
A4 hi nq3 NULL NULL q4 nq4 tff10
A5 hi nq4 NULL NULL q5 nq5 tff10
A6 hi nq5 NULL NULL q6 nq6 tff10
A7 hi nq6 NULL NULL q7 nq7 tff10
* decoder of count 0
Adec [q0 q1 q2 q3 q4 q5 q6 q7] z0 nor8
Ada [q0 q6 q7 z0] [b0 b6 b7 cero] toAna
.tran 0.1n 25.7u 25.4u 0.1n
.control
  run
  * edge 128 is at 100 ns + 127 * 200 ns = 25.5 us
  meas tran t_b0 when v(b0)=2.5 fall=1
  meas tran t_b6 when v(b6)=2.5 fall=1
  meas tran t_b7 when v(b7)=2.5 rise=1
  let r_b0 = (t_b0 - 25.5u) * 1e9
  let r_b7 = (t_b7 - 25.5u) * 1e9
  let b7_b0 = (t_b7 - t_b0) * 1e9
  echo "Retardo del bit 0 y del bit 7 respecto al flanco 128, y entre ambos (ns); esperado 10, 80 y 70:"
  print r_b0 r_b7 b7_b0
  meas tran pulso_cero trig v(cero) val=2.5 rise=1 targ v(cero) val=2.5 fall=1
  echo "pulso_cero: pulso falso del decodificador de la cuenta 0, esperado 10 ns"
.endc
.end
