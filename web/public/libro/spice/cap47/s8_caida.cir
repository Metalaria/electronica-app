* Bench circuit: 25 m of 2.5 mm2 (9.548 ohm/km at 70 C) per conductor, load 2200 VA as a current source
V1 a 0 AC 230 0
RLF a b 0.2387018
I1 b c AC 9.565217
RLN c 0 0.2387018
.ac lin 1 50 50
.end
