* Three-phase bridge on 400/230 V, 470 uF bus, 100 ohm load; insulation fault DC+ to the case through 1k
V1 a nt SIN(0 326.6 50 0 0 0)
V2 b nt SIN(0 326.6 50 0 0 -120)
V3 c nt SIN(0 326.6 50 0 0 120)
RB nt 0 2
RA1 a a1 0.2
RB1 b b1 0.2
RC1 c c1 0.2
D1 a1 p DX
D2 b1 p DX
D3 c1 p DX
D4 m a1 DX
D5 m b1 DX
D6 m c1 DX
C1 p m 470u
RLOAD p m 100
RF p pe 1k
VF pe pe2 0
RA pe2 0 20
.model DX D(IS=1e-9 N=1.5 RS=0.02 CJO=20p)
.options method=gear
.tran 20u 0.3 0 20u
.end
