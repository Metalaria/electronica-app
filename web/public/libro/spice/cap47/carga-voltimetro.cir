* Sección 47.2, «Por carga»: un multímetro de 10 Mohm sobre una fuente de 1 Mohm.
* Fuente de 10 V con 1 Mohm de resistencia interna, cargada con la entrada de 10 Mohm del multímetro.
* Comprueba: la lectura es 10/11 del valor real (9,09 V), algo más de un 9 % por debajo.
* Ejecutar: ngspice -b carga-voltimetro.cir
V1 a 0 DC 10
RF a m 1Meg
RDMM m 0 10Meg
.control
  op
  print v(m)
  let error_pct = 100*(10 - v(m))/10
  print error_pct
.endc
.end
