* fig-47.6 y fig-47.7 (sección 47.4), fig-47.9 (sección 47.6), ejercicio 47.3 y problema 47.B:
* la cadena térmica resuelta como circuito por la analogía de la sección 47.4
* (temperatura = tensión en V, potencia = corriente en A, °C/W = ohm; el ambiente es una fuente de tensión).
* Comprueba:
*  - sección 47.4: 10 W, Rjc 1, Rcs 0,5, Rsa 2, 40 °C -> Ts 60, Tc 65, Tj 75 °C;
*  - sección 47.6: 5 W, Rjc 1,5, Rcs 1, Rsa 13,5, 40 °C -> Tj 120 °C (justo el criterio de diseño);
*  - ejercicio 47.3: 4 W, Rjc + Rcs 2, Rsa 19,25, 40 °C -> Tj 125 °C (justo el límite);
*  - problema 47.B: 15 W con Rsa de 5, 1,5 y 0,7 °C/W -> salto del disipador 75, 22,5 y 10,5 °C.
* Ejecutar: ngspice -b fig-47.6.cir
* --- section 47.4
IP1 0 j1 DC 10
RJC1 j1 c1 1
RCS1 c1 s1 0.5
RSA1 s1 a1 2
VTA1 a1 0 DC 40
* --- section 47.6
IP2 0 j2 DC 5
RJC2 j2 c2 1.5
RCS2 c2 s2 1
RSA2 s2 a2 13.5
VTA2 a2 0 DC 40
* --- exercise 47.3
IP3 0 j3 DC 4
RJCS3 j3 s3 2
RSA3 s3 a3 19.25
VTA3 a3 0 DC 40
* --- problem 47.B (heatsink rise only)
IP4 0 s4 DC 15
RSA4 s4 0 5
.control
  op
  echo "seccion 47.4: Tj Tc Ts"
  print v(j1) v(c1) v(s1)
  echo "seccion 47.6: Tj"
  print v(j2)
  echo "ejercicio 47.3: Tj"
  print v(j3)
  echo "problema 47.B: salto del disipador con Rsa = 5, 1.5, 0.7"
  print v(s4)
  alter RSA4 1.5
  op
  print v(s4)
  alter RSA4 0.7
  op
  print v(s4)
.endc
.end
