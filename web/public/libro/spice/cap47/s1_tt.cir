* TT fault: phase to the case of a class I appliance; RB = 2 ohm, RA = 20 ohm, person 1 kohm case-earth
V1 l nt AC 230 0
RB nt 0 2
RF l m 1m
VA m ma 0
RA ma 0 20
VP m mp 0
RP mp 0 1k
.ac lin 1 50 50
.end
