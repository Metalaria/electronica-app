* Exercise 46.6: TT fault, RB = 3 ohm, RA = 40 ohm
V1 l nt AC 230 0
RB nt 0 3
RF l m 1m
VA m ma 0
RA ma 0 40
.ac lin 1 50 50
.end
