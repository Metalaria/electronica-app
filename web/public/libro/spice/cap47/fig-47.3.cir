* fig-47.3 (sección 47.2 y ejercicio 47.2): carga de una sonda ×1 y de una ×10 sobre un circuito
* con 10 kohm de resistencia de salida. Entrada del osciloscopio: 1 Mohm || 100 pF (entrada más cable).
* Sonda ×10: punta 9 Mohm || Ccomp, con Ccomp = 1M·100p/9M = 11,1 pF (compensación exacta), más unos
* 2 pF parásitos de la propia punta. El circuito ve entonces 10 Mohm || ≈ 12 pF.
* Comprueba: corte de 160 kHz con la ×1 y de unos 1,3 MHz con la ×10; con la ×10 llega 0,1 V a la
* entrada del osciloscopio (el ajuste ×10 de la pantalla lo devuelve a 1 V); respuesta plana gracias a
* la compensación.
* Ejecutar: ngspice -b fig-47.3.cir
* --- sonda ×1
V1 s1 0 DC 0 AC 1
RS1 s1 t1 10k
RIN1 t1 0 1Meg
CIN1 t1 0 100p
* --- sonda ×10
V2 s2 0 DC 0 AC 1
RS2 s2 t2 10k
CTIP t2 0 2p
RP t2 sc 9Meg
CCOMP t2 sc 11.11p
RIN2 sc 0 1Meg
CIN2 sc 0 100p
.ac dec 200 1k 100Meg
.control
  run
  meas ac f1 WHEN vdb(t1)=-3.0103
  meas ac f10 WHEN vdb(t2)=-3.0103
  meas ac g10_1k FIND vm(sc) AT=1k
  meas ac g10_100k FIND vm(sc) AT=100k
  let cvista = 1/(2*pi*10k*f10)
  print cvista
.endc
.end
