* P10 (cap57, section 57.3): one phase of the 17HS4401 stepper (1.5 ohm, 2.8 mH) reversed by the full bridge
* from -1.5 A to +1.5 A at 12 V and at 24 V (no back EMF: the motor at standstill). Run: ngspice -b paso_inversion.cir
* Expected: 0.708 ms at 12 V and 0.351 ms at 24 V (the chapter rounds to 2*L*I/V = 0.70 and 0.35 ms).
.param L=2.8m R=1.5
V12 a12 0 DC 12
R12 a12 b12 {R}
L12 b12 0 {L} IC=-1.5
V24 a24 0 DC 24
R24 a24 b24 {R}
L24 b24 0 {L} IC=-1.5
.tran 1u 1.5m 0 1u uic
.control
run
meas tran t12 WHEN i(L12)=1.5 RISE=1
meas tran t24 WHEN i(L24)=1.5 RISE=1
print t12 t24
.endc
.end
