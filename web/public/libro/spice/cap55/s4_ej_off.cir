* P03 exercise: 1.5 mA residual into a 3.9 kohm input with an 18 kohm bleeder
V24 p 0 DC 24
ISENS p in DC 1.5m
RIN in 0 3.9k
RP in 0 18k
.op
.end
