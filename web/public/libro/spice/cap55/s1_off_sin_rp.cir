* P03: two-wire sensor OFF (1.5 mA residual) into a 4.7 kohm input, no bleeder
V24 p 0 DC 24
ISENS p in DC 1.5m
RIN in 0 4.7k
.op
.end
