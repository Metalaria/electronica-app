* Seccion 21.14 (Modo X-Y: el trazador de curvas, "En el banco"): generador senoidal, 1 kohm en
* serie y el componente (aqui un 1N4148). X = tension del diodo; Y = caida en la resistencia
* (1 V por mA). Dos generadores:
*  (a) senoide simetrica de 3 V de pico a 50 Hz: se ve la rodilla directa (~0,6-0,7 V) y la
*      inversa pegada al eje (corriente de fuga despreciable);
*  (b) el generador del 2C53T, cuya salida es siempre positiva (0 a 3 V, es decir 1,5 V de
*      continua + 1,5 V de pico): la tension del diodo nunca se hace negativa, asi que solo se
*      dibuja el primer cuadrante.
* Ejecutar:  ngspice -b sec-21.14_trazador_curvas.cir
.model D1N4148 D(IS=2.52n RS=0.568 N=1.752 CJO=4p M=0.4 TT=20n BV=100 IBV=100u)
VA ga 0 SIN(0 3 50)
RA ga da 1k
DA da 0 D1N4148
VB gb 0 SIN(1.5 1.5 50)
RB gb db 1k
DB db 0 D1N4148
.control
tran 20u 60m
meas tran vd_dir_a max v(da) from=20m to=60m
meas tran vd_inv_a min v(da) from=20m to=60m
meas tran id_max_a max i(VA) from=20m to=60m
meas tran id_min_a min i(VA) from=20m to=60m
meas tran vd_dir_b max v(db) from=20m to=60m
meas tran vd_min_b min v(db) from=20m to=60m
.endc
.end
