* Seccion 21.16 (El generador: impedancia de salida y el "factor dos") y figura 21.31
* (tension de carga del amperimetro).
* (1) Generador de 50 ohm programado para 1 V de pico sobre 50 ohm: su fuente interna vale 2 V.
*     Sobre 50 ohm da 1 V; en circuito abierto (1 Mohm del osciloscopio) da el doble, 2 V.
* (2) Amperimetro en el rango de mA con un shunt de ~10 ohm (lo que supone la figura 21.31):
*     50 mA cuestan 0,5 V. En un circuito de 5 V y 100 ohm (50 mA sin medidor), intercalarlo
*     baja la corriente a 45,5 mA: el instrumento altera lo que mide. En el rango de A (~0,01 ohm)
*     la caida es de 0,5 mV y la corriente apenas cambia.
* Ejecutar:  ngspice -b sec-21.16_generador_y_amperimetro.cir
VG1 g1 0 2
RO1 g1 o1 50
RL1 o1 0 50
VG2 g2 0 2
RO2 g2 o2 50
RL2 o2 0 1Meg
* fuente de corriente ideal de 50 mA por el shunt de mA
I1 0 s1 50m
RSH1 s1 0 10
* circuito real de 5 V / 100 ohm con el amperimetro intercalado
V5 c5 0 5
RC c5 m5 100
RSH2 m5 0 10
V6 c6 0 5
RC6 c6 m6 100
RSH3 m6 0 0.01
.control
op
print v(o1) v(o2)
print v(s1)
print -i(V5) v(m5)
print -i(V6) v(m6)
.endc
.end
