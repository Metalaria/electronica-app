* Secciones 21.20 y 21.17 (Ancho de banda y tiempo de subida) y figuras 21.36 y 21.45.
* El canal del osciloscopio se modela como un polo simple de 50 MHz: R = 1 kohm, C = 3,183 pF
* (tau = 3,18 ns, t_r = 2,2*tau = 0,35/50 MHz = 7 ns).
* (1) .ac: amplitud mostrada a 5, 10, 25, 50 y 100 MHz (tabla de la seccion 21.20:
*     99,5 %, 98 %, 89 %, 71 %, 45 %).
* (2) .tran: un escalon ideal (da el t_r propio del instrumento) y flancos "reales" de 5; 7,14;
*     18,7 y 49,5 ns (cada uno generado con su propio polo simple y separado del canal con un
*     VCVS) vistos a traves del canal. Se mide el 10-90 % de entrada y de salida para comprobar
*     la suma en cuadratura de la seccion 21.17: 5 -> 8,6 ns; 7,1 -> 10 ns; 18,7 -> 20 ns;
*     49,5 -> 50 ns. La suma en cuadratura es exacta para respuestas gaussianas; con dos polos
*     simples sale un 5-8 % mas (5 -> 9,2 ns; 7,1 -> 10,8 ns), y por eso el texto la da como
*     aproximacion.
* Ejecutar:  ngspice -b sec-21.20_ancho_banda_subida.cir
VAC a 0 DC 0 AC 1
RA a oa 1k
CA oa 0 3.1831p
VST st 0 PULSE(0 1 10n 1p 1p 2u 4u)
R0 st o0 1k
C0 o0 0 3.1831p
* flanco real de 5 ns
RG5 st g5 1k
CG5 g5 0 2.27562e-12
E5 b5 0 g5 0 1
RS5 b5 o5 1k
CS5 o5 0 3.1831p
* flanco real de 7.14 ns
RG7 st g7 1k
CG7 g7 0 3.24959e-12
E7 b7 0 g7 0 1
RS7 b7 o7 1k
CS7 o7 0 3.1831p
* flanco real de 18.7 ns
RG19 st g19 1k
CG19 g19 0 8.51083e-12
E19 b19 0 g19 0 1
RS19 b19 o19 1k
CS19 o19 0 3.1831p
* flanco real de 49.5 ns
RG50 st g50 1k
CG50 g50 0 2.25287e-11
E50 b50 0 g50 0 1
RS50 b50 o50 1k
CS50 o50 0 3.1831p
.control
ac lin 1 5Meg 5Meg
let a5 = vm(oa)
print a5
ac lin 1 10Meg 10Meg
let a10 = vm(oa)
print a10
ac lin 1 25Meg 25Meg
let a25 = vm(oa)
print a25
ac lin 1 50Meg 50Meg
let a50 = vm(oa)
print a50
ac lin 1 100Meg 100Meg
let a100 = vm(oa)
print a100
tran 0.05n 600n
meas tran t10_inst when v(o0)=0.1 rise=1
meas tran t90_inst when v(o0)=0.9 rise=1
let tr_instrumento = t90_inst-t10_inst
print tr_instrumento
meas tran t10_tr_real_5 when v(g5)=0.1 rise=1
meas tran t90_tr_real_5 when v(g5)=0.9 rise=1
let tr_real_5 = t90_tr_real_5-t10_tr_real_5
print tr_real_5
meas tran t10_tr_visto_5 when v(o5)=0.1 rise=1
meas tran t90_tr_visto_5 when v(o5)=0.9 rise=1
let tr_visto_5 = t90_tr_visto_5-t10_tr_visto_5
print tr_visto_5
meas tran t10_tr_real_7 when v(g7)=0.1 rise=1
meas tran t90_tr_real_7 when v(g7)=0.9 rise=1
let tr_real_7 = t90_tr_real_7-t10_tr_real_7
print tr_real_7
meas tran t10_tr_visto_7 when v(o7)=0.1 rise=1
meas tran t90_tr_visto_7 when v(o7)=0.9 rise=1
let tr_visto_7 = t90_tr_visto_7-t10_tr_visto_7
print tr_visto_7
meas tran t10_tr_real_19 when v(g19)=0.1 rise=1
meas tran t90_tr_real_19 when v(g19)=0.9 rise=1
let tr_real_19 = t90_tr_real_19-t10_tr_real_19
print tr_real_19
meas tran t10_tr_visto_19 when v(o19)=0.1 rise=1
meas tran t90_tr_visto_19 when v(o19)=0.9 rise=1
let tr_visto_19 = t90_tr_visto_19-t10_tr_visto_19
print tr_visto_19
meas tran t10_tr_real_50 when v(g50)=0.1 rise=1
meas tran t90_tr_real_50 when v(g50)=0.9 rise=1
let tr_real_50 = t90_tr_real_50-t10_tr_real_50
print tr_real_50
meas tran t10_tr_visto_50 when v(o50)=0.1 rise=1
meas tran t90_tr_visto_50 when v(o50)=0.9 rise=1
let tr_visto_50 = t90_tr_visto_50-t10_tr_visto_50
print tr_visto_50
.endc
.end
