* Seccion 21.7 (Acoplamiento AC) y figura 21.35: el acoplamiento AC es un paso alto.
* Condensador de acoplo + 1 Mohm de entrada con corte en unos 10 Hz: C = 1/(2*pi*10*1Meg) = 15,9 nF.
* Tres comprobaciones del texto:
*  (1) Tren de pulsos de 5 V al 10 % (1 kHz): en regimen permanente el condensador promedia a
*      cero y el pulso se ve de +4,5 V a -0,5 V.
*  (2) Cuadrada de 100 Hz (0-5 V): la meseta aparece inclinada (el condensador se descarga
*      durante el semiciclo de 5 ms, que es 0,31 tau).
*  (3) Cuadrada de 1 Hz: el semiciclo de 0,5 s son 31 tau, asi que cada flanco se ve como un
*      pico que decae del todo a cero: no queda meseta inclinada, sino picos.
* Ejecutar:  ngspice -b sec-21.7_acoplo_ac.cir
.param cac=15.9n
V1 p1 0 PULSE(0 5 0 1n 1n 100u 1m)
C1 p1 o1 {cac}
R1 o1 0 1Meg
V2 p2 0 PULSE(0 5 0 1n 1n 5m 10m)
C2 p2 o2 {cac}
R2 o2 0 1Meg
V3 p3 0 PULSE(0 5 0 1n 1n 0.5 1)
C3 p3 o3 {cac}
R3 o3 0 1Meg
.control
tran 5u 3.6
meas tran pulso_max max v(o1) from=0.300 to=0.301
meas tran pulso_min min v(o1) from=0.300 to=0.301
meas tran c100_ini find v(o2) at=0.300001
meas tran c100_fin find v(o2) at=0.304999
meas tran c1_ini   find v(o3) at=3.000001
meas tran c1_50ms  find v(o3) at=3.05
meas tran c1_fin   find v(o3) at=3.499
.endc
.end
