* Seccion 21.8 (La sonda x1 frente a x10: por que la capacidad manda) y figura 21.16.
* Una fuente de 10 kohm de impedancia medida con la sonda en x1 (1 Mohm || ~100 pF: cable
* coaxial + entrada) y en x10 (10 Mohm || ~12 pF). La capacidad forma con la fuente un paso
* bajo; el texto da 160 kHz para x1, unos 800 kHz para la P6100 en x10 (18,5-22,5 pF segun su
* hoja, unos 20 pF) y 1,3 MHz para una sonda x10 de 12 pF.
* Se miden las frecuencias de -3 dB con un barrido .ac.
* Ejecutar:  ngspice -b sec-21.8_carga_sonda.cir
VS s 0 DC 0 AC 1
* sonda x1
RS1 s n1 10k
RP1 n1 0 1Meg
CP1 n1 0 100p
* sonda x10 de 12 pF (vista desde la punta)
RS10 s n10 10k
RP10 n10 0 10Meg
CP10 n10 0 12p
* sonda x10 P6100 (~20 pF)
RS20 s n20 10k
RP20 n20 0 10Meg
CP20 n20 0 20p
.control
ac dec 200 1k 100Meg
let ref1 = vm(n1)[0]/sqrt(2)
let ref10 = vm(n10)[0]/sqrt(2)
let ref20 = vm(n20)[0]/sqrt(2)
meas ac fc_x1  when vm(n1)=$&ref1
meas ac fc_x10 when vm(n10)=$&ref10
meas ac fc_x10_p6100 when vm(n20)=$&ref20
.endc
.end
