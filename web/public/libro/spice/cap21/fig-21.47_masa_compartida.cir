* fig-21.47 / seccion 21.21 (La masa del osciloscopio): los dos canales comparten la pinza de masa.
* Circuito de la figura: 12 V, R1 arriba (nodo A a nodo B) y R2 abajo (nodo B a masa).
* Se toman R1 = R2 = 1 kohm (la figura no da valores). Las dos pinzas de masa estan unidas
* dentro del instrumento; la union se modela con 0,1 ohm.
* Montaje MAL: CH1 punta en B, pinza en masa; CH2 punta en A, pinza en B. La pinza de CH2 une B
*   con la pinza de CH1, es decir, con masa: R2 queda en cortocircuito (V(B) = 0, la corriente
*   pasa de 6 mA a 12 mA y R1 disipa cuatro veces mas).
* Montaje BIEN: las dos pinzas en masa, CH1 en A y CH2 en B; V(R1) = CH1 - CH2 (funcion Math).
* Ejecutar:  ngspice -b fig-21.47_masa_compartida.cir
* --- montaje correcto ---
VB1 a1 0 12
R1b a1 b1 1k
R2b b1 0 1k
* --- montaje incorrecto: la pinza de CH2 en B queda unida a masa por el instrumento ---
VB2 a2 0 12
R1m a2 b2 1k
R2m b2 0 1k
RPINZAS b2 0 0.1
.control
op
print v(a1) v(b1) v(a1)-v(b1)
print v(b2) v(a2)-v(b2)
print -i(VB1)
print -i(VB2)
.endc
.end
