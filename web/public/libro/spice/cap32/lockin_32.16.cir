* Seccion 32.16, "El detector sincrono, paso a paso": producto de dos senoides y filtro de salida.
* Senal de 10 mV a 1 kHz con desfase de 60 grados respecto a una referencia de 1 V; se
* multiplican (fuente B, sin ruido) y se filtran con un RC de tau = 0,1 s.
* Texto: el producto da 1/2 * Vref * Vsenal * cos(phi) en continua mas un termino a 2f.
*   Aqui: 0,5 * 1 * 0,01 * cos 60 = 2,5 mV. Banda equivalente de ruido del filtro: 1/(4 tau) = 2,5 Hz.
* Ejecutar:  ngspice -b lockin_32.16.cir
* Resultado (ngspice-42): salida media 2,500 mV tras 1 s (10 tau); sin el 1/2 serian 5 mV.
Vref r 0 SIN(0 1 1k 0 0 0)
Vsig s 0 SIN(0 10m 1k 0 0 60)
Bmul m 0 V = V(r)*V(s)
Rf m o 100k
Cf o 0 1u
.tran 10u 1.2 0 10u
.meas tran vdc AVG v(o) FROM=1.0 TO=1.2
.end
