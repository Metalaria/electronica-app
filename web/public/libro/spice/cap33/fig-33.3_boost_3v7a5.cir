* fig-33.3 (sección 33.3): elevador síncrono ideal de 3,7 V (batería) a 5 V con 1 A de salida.
* Comprueba: D = 1 - 3,7/5 = 0,26 da Vout = 5 V y una corriente media de entrada de 1,35 A.
* Segunda parte: a t = 1 ms el ciclo de trabajo sube en escalón de 0,26 a 0,30 (lo que haría el lazo
* ante un aumento de carga). La salida BAJA primero y solo después sube hacia 3,7/0,70 = 5,29 V:
* es el cero en el semiplano derecho de la figura 33.3.
* Valores no dados por el libro (los mismos que usa la figura): L = 47 uH, C = 10 uF, fs = 500 kHz.
* Como el rizado de conmutación (unos 50 mV) tapa el efecto, se miden medias de un periodo.
* PWM por comparación de una rampa con la tensión de control VC.
* Ejecutar: ngspice -b fig-33.3_boost_3v7a5.cir
.param fs=500k T={1/fs}
VIN  in 0 DC 3.7
VRMP rmp 0 PULSE(0 1 0 {T-2n} 1n 1n {T})
VC   vc 0 PWL(0 0.26 1m 0.26 1.0001m 0.30)
BG1  g1 0 V = v(vc) > v(rmp) ? 1 : 0
BG2  g2 0 V = v(vc) > v(rmp) ? 0 : 1
VSEN in a DC 0
L1   a sw 47u IC=1.351
S1   sw 0   g1 0 SWI
S2   sw out g2 0 SWI
C1   out 0 10u IC=5
RL   out 0 5
.model SWI SW(Ron=1m Roff=1e7 Vt=0.5 Vh=0)
.tran 5n 3m 0 5n uic
.control
run
meas tran vout_med AVG v(out) from=0.9m to=1m
meas tran iin_med AVG i(VSEN) from=0.9m to=1m
meas tran v_ciclo0 AVG v(out) from=0.998m to=1.000m
meas tran v_ciclo1 AVG v(out) from=1.000m to=1.002m
meas tran v_ciclo3 AVG v(out) from=1.004m to=1.006m
meas tran v_ciclo5 AVG v(out) from=1.008m to=1.010m
meas tran v_ciclo10 AVG v(out) from=1.018m to=1.020m
meas tran v_ciclo20 AVG v(out) from=1.038m to=1.040m
meas tran v_ciclo40 AVG v(out) from=1.078m to=1.080m
meas tran vout_fin AVG v(out) from=2.9m to=3m
echo "Texto: D = 0,26 -> 5 V; Iin >= 1,35 A. Tras el escalón la media por ciclo baja primero y luego sube (~5,29 V)"
.endc
.end
