* Problema 33.C (sección 33.17): elevador ideal desde 5 V con 1 A de salida y distintos ciclos de trabajo.
* Cuatro circuitos idénticos con D = 0,50 / 0,80 / 0,90 / 0,95 y carga Vout/1 A (10, 25, 50 y 100 ohm).
* Comprueba: Vout = Vin/(1-D) = 10 / 25 / 50 / 100 V y corriente de entrada = Iout/(1-D) = 2 / 5 / 10 / 20 A;
* con D = 0,95 a 300 kHz la descarga dura (1-D)*T = 167 ns.
* Valores no dados por el libro (típicos): L = 22 uH, C = 100 uF, fs = 300 kHz; interruptores ideales.
* Ejecutar: ngspice -b prob-33.C_boost_ciclo.cir
.param fs=300k T={1/fs}
.model SWI SW(Ron=1m Roff=1e8 Vt=0.5 Vh=0)
.subckt boost out isen PARAMS: D=0.5 R=10 VO=10 IL=2
VIN  in 0 DC 5
VSEN in a DC 0
* la corriente de entrada se copia en el nodo isen (1 V = 1 A) para medirla desde fuera
BIS  isen 0 V = i(VSEN)
* arranque en el mínimo de la rampa de corriente (IL - dI/2), que es el estado real al empezar
* la conducción; así el filtro apenas se excita y el régimen llega enseguida
L1   a sw 22u IC={IL-5*D/(fs*22u)/2}
VG1  g1 0 PULSE(0 1 0 1n 1n {D*T-1n} {T})
VG2  g2 0 PULSE(1 0 0 1n 1n {D*T-1n} {T})
S1   sw 0   g1 0 SWI
S2   sw out g2 0 SWI
C1   out 0 100u IC={VO+D/(fs*100u)/2}
RL   out 0 {R}
.ends
X50 o50 i50 boost PARAMS: D=0.50 R=10  VO=10  IL=2
X80 o80 i80 boost PARAMS: D=0.80 R=25  VO=25  IL=5
X90 o90 i90 boost PARAMS: D=0.90 R=50  VO=50  IL=10
X95 o95 i95 boost PARAMS: D=0.95 R=100 VO=100 IL=20
.tran 10n 20m 19m 10n uic
.control
run
meas tran vout_050 AVG v(o50) from=19m to=20m
meas tran iin_050  AVG v(i50) from=19m to=20m
meas tran vout_080 AVG v(o80) from=19m to=20m
meas tran iin_080  AVG v(i80) from=19m to=20m
meas tran vout_090 AVG v(o90) from=19m to=20m
meas tran iin_090  AVG v(i90) from=19m to=20m
meas tran vout_095 AVG v(o95) from=19m to=20m
meas tran iin_095  AVG v(i95) from=19m to=20m
echo "Texto: 10 V / 2 A; 25 V / 5 A; 50 V / 10 A; 100 V / 20 A"
.endc
.end
