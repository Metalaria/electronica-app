* fig-33.10 (sección 33.9): estados de un puente en H con un motor de continua.
* Motor modelado como R = 1 ohm, L = 1 mH y fuerza contraelectromotriz fija de 12 V (en estos
* milisegundos la velocidad apenas cambia). Bus de 24 V. Interruptores S1 (alto izq.), S2 (alto der.),
* S3 (bajo izq.), S4 (bajo der.), cada uno con su diodo en antiparalelo.
* Secuencia: 0-3 ms avance (S1 y S4); 3-3,5 ms rueda libre con todo abierto; 3,5-4 ms avance otra vez;
* 4-6 ms frenado (S3 y S4).
* Comprueba: en avance la corriente sube hacia (24-12)/1 = 12 A; en rueda libre la corriente del motor
* decae por los diodos D2 y D3 y la corriente de la fuente se invierte (el motor DEVUELVE energía al bus);
* en frenado el motor queda en cortocircuito por S3 y S4: su fuerza contraelectromotriz invierte la corriente
* (par de frenado), que tiende a -12/1,04 = -11,5 A, y la fuente no entrega nada.
* Valores no dados por el libro (típicos). Ejecutar: ngspice -b fig-33.10_puente_h.cir
VBUS bus 0 DC 24
VSEN bus top DC 0
VG1  g1 0 PWL(0 1 3m 1 3.001m 0 3.5m 0 3.501m 1 4m 1 4.001m 0)
VG4  g4 0 PWL(0 1 3m 1 3.001m 0 3.5m 0 3.501m 1 6m 1)
VG3  g3 0 PWL(0 0 4.05m 0 4.051m 1)
S1   top a g1 0 SWI
S2   top b 0 0 SWI
S3   a 0 g3 0 SWI
S4   b 0 g4 0 SWI
D1   a top DPOT
D2   b top DPOT
D3   0 a DPOT
D4   0 b DPOT
* motor entre a y b
VMS  a m1 DC 0
RM   m1 m2 1
LM   m2 m3 1m
VEMF m3 b DC 12
.model SWI SW(Ron=20m Roff=1e7 Vt=0.5 Vh=0)
.model DPOT D(IS=1e-9 N=1.5 RS=10m TT=50n BV=100)
.tran 1u 6m 0 1u
.control
run
meas tran im_avance FIND i(VMS) AT=2.99m
meas tran ibus_avance FIND i(VSEN) AT=2.99m
meas tran ibus_rueda_libre FIND i(VSEN) AT=3.002m
meas tran im_rueda_libre FIND i(VMS) AT=3.002m
meas tran t_cero WHEN i(VMS)=0.01 FALL=1 TD=3m
meas tran ibus_frenado FIND i(VSEN) AT=5.9m
meas tran im_frenado FIND i(VMS) AT=5.9m
echo "Texto: rueda libre -> la corriente del bus se invierte (vuelve energía a la fuente); frenado -> corriente invertida por S3-S4, bus a 0"
.endc
.end
