* Sección 23.5, ejemplo de superposición (el mismo de la sección 1.5): fuentes de 12 V y 6 V,
* cada una con 1 k en serie, sobre una carga común de 2 k.
* Comprueba: la de 12 V sola aporta 4,80 V, la de 6 V sola 2,40 V, juntas 7,20 V; y que la potencia
* en la carga (25,92 mW) NO es la suma de las parciales (11,52 + 2,88 = 14,40 mW).
* Ejecutar: ngspice -b superposicion_23.5.cir
* las dos fuentes
VA1 a1 0 DC 12
RA1 a1 n1 1k
VB1 b1 0 DC 6
RB1 b1 n1 1k
RL1 n1 0 2k
* solo la de 12 V (la de 6 V, cortocircuito)
VA2 a2 0 DC 12
RA2 a2 n2 1k
RB2 n2 0 1k
RL2 n2 0 2k
* solo la de 6 V (la de 12 V, cortocircuito)
RA3 n3 0 1k
VB3 b3 0 DC 6
RB3 b3 n3 1k
RL3 n3 0 2k
.control
op
let suma = v(n2)+v(n3)
print v(n1) v(n2) v(n3) suma
let ptotal = v(n1)^2/2k
let psuma = v(n2)^2/2k + v(n3)^2/2k
print ptotal psuma
.endc
.end
