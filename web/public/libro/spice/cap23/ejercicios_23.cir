* Ejercicios del capítulo 23.
* ej-23.1: nodo A con 10 V por 2 ohm, 2 ohm a masa y 5 V por 1 ohm: V_A = 5 V.
* ej-23.2/23.3/23.4: 10 V con R1 = 2 ohm en serie y R2 = 8 ohm entre a y b: V_th = 8 V,
*   I_N = 5 A, R_th = 1,6 ohm; con R_L = 1,6 ohm, P_max = 10 W.
* ej-23.6: 12 V por 2 k, 5 V por 1 k y 3 k a masa: V = 6,0 V.
* Ejecutar: ngspice -b ejercicios_23.cir
* ej-23.1
VA1 x1 0 DC 10
RA1 x1 A 2
RA2 A 0 2
RA3 A x3 1
VA3 x3 0 DC 5
* ej-23.2 en vacío
VB1 y1 0 DC 10
RB1 y1 b1 2
RB2 b1 0 8
* ej-23.3 en cortocircuito
VC1 y2 0 DC 10
RC1 y2 b2 2
RC2 b2 0 8
VSC b2 0 DC 0
* ej-23.4 con la carga óptima
VD1 y3 0 DC 10
RD1 y3 b3 2
RD2 b3 0 8
RLD b3 0 1.6
* ej-23.6
VE1 z1 0 DC 12
RE1 z1 m 2k
VE2 z2 0 DC 5
RE2 z2 m 1k
RE3 m 0 3k
.control
op
print v(A)
let vth = v(b1)
let isc = i(VSC)
let rth = vth/isc
print vth isc rth
let pl = v(b3)^2/1.6
print v(b3) pl
print v(m)
.endc
.end
