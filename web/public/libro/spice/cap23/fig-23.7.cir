* Figura 23.7 y sección 23.6, «La medida experimental»: R_Th = R_L (V_vacío/V_carga - 1).
* Caso 1: salida de 5,00 V con R_Th = 3,093 ohm (el valor que el texto deduce, 3,1 ohm) y carga de
*         100 ohm: debe leerse 4,85 V con carga.
* Caso 2: pila de 9 V con 5 ohm internos y carga de 45 ohm (sección 1.10): 8,1 V, 180 mA,
*         1,458 W en la carga y 0,162 W en la resistencia interna.
* Ejecutar: ngspice -b fig-23.7.cir
V1  s1 0 DC 5
RT1 s1 o1 3.093
RL1 o1 0 100
V2  s2 0 DC 9
RT2 s2 o2 5
RL2 o2 0 45
.control
op
print v(o1)
let rth1 = 100*(5/v(o1)-1)
print rth1
let il = v(o2)/45
let pl = v(o2)*il
let pint = 5*il^2
let rth2 = (9-v(o2))/il
print v(o2) il pl pint rth2
.endc
.end
