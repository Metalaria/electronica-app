* Figura 23.9 (sección 23.8): transformación de fuentes en cadena. Entre a y b: 12 V con 4 ohm en
* serie, 3 ohm, y una fuente de 2 A que inyecta en a.
* Comprueba: tensión en vacío 60/7 = 8,571 V y R_Th = 4 || 3 = 12/7 = 1,714 ohm (la fuente
* equivalente final de la figura), y que el equivalente da lo mismo con una carga de 2 ohm.
* Ejecutar: ngspice -b fig-23.9.cir
* red original en vacío
V1  s1 0 DC 12
R41 s1 a1 4
R31 a1 0 3
I21 0 a1 DC 2
* red original en cortocircuito
V2  s2 0 DC 12
R42 s2 a2 4
R32 a2 0 3
I22 0 a2 DC 2
VSC a2 0 DC 0
* red original con 2 ohm de carga
V3  s3 0 DC 12
R43 s3 a3 4
R33 a3 0 3
I23 0 a3 DC 2
RL3 a3 0 2
* equivalente final: 8,571 V con 1,714 ohm, con la misma carga
VE  se 0 DC {60/7}
RE  se ae {12/7}
RLE ae 0 2
.control
op
let vth = v(a1)
let rth = vth/i(VSC)
print vth rth v(a3) v(ae)
.endc
.end
