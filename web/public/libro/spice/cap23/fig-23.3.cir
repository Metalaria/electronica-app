* Figura 23.3 y Ec. 3 (sección 23.3): circuito con un solo nodo esencial A.
* Fuente de 10 V -- R1 = 2 ohm -- nodo A -- R3 = 3 ohm -- fuente de 6 V; R2 = 4 ohm de A a masa.
* Comprueba: V_A = 84/13 = 6,4615 V y que la suma de corrientes que salen de A es cero.
* Ejecutar: ngspice -b fig-23.3.cir
V10 s1 0 DC 10
R1  s1 A 2
R2  A 0 4
R3  A s2 3
V6  s2 0 DC 6
.control
op
print v(A)
let i1 = (v(A)-10)/2
let i2 = v(A)/4
let i3 = (v(A)-6)/3
print i1 i2 i3
let suma = i1+i2+i3
print suma
.endc
.end
