* Sección 23.3, «Un ejemplo mínimo»: fuente de corriente de 2 A que inyecta en el nodo 1;
* 10 ohm del nodo 1 a masa, 5 ohm entre los nodos 1 y 2, 20 ohm del nodo 2 a masa.
* Comprueba: V1 = 14,29 V, V2 = 11,43 V; 1,43 A por los 10 ohm y 0,57 A por los 5 ohm, que suman 2 A.
* Ejecutar: ngspice -b ejemplo_nodal_23.3.cir
I1  0 n1 DC 2
R10 n1 0 10
R5  n1 n2 5
R20 n2 0 20
.control
op
print v(n1) v(n2)
let i10 = v(n1)/10
let i5 = (v(n1)-v(n2))/5
let suma = i10+i5
print i10 i5 suma
.endc
.end
