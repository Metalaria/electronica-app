* Figura 23.8 y sección 23.7: fuente de 12 V con 4 ohm internos alimentando 8 ohm, resuelta como
* Thévenin (divisor de tensión) y como Norton (3 A en paralelo con 4 ohm, divisor de corriente).
* Comprueba: 8 V y 1 A en la carga por los dos caminos; I_N = 12/4 = 3 A.
* Ejecutar: ngspice -b fig-23.8.cir
* forma Thévenin
VT  s 0 DC 12
RT  s ot 4
RLT ot 0 8
* forma Norton
IN  0 on DC 3
RN  on 0 4
RLN on 0 8
.control
op
let ilt = v(ot)/8
let iln = v(on)/8
print v(ot) ilt v(on) iln
.endc
.end
