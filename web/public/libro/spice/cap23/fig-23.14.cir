* Figura 23.14 y sección 23.12 (teorema de Millman): tres ramas al mismo nodo, 12 V por 1 k,
* 5 V por 2 k y masa por 4,7 k.
* Comprueba: V = 14,5 mA / 1,713 mS = 8,47 V.
* Ejecutar: ngspice -b fig-23.14.cir
V1 s1 0 DC 12
R1 s1 n 1k
V2 s2 0 DC 5
R2 s2 n 2k
R3 n 0 4.7k
.control
op
print v(n)
.endc
.end
