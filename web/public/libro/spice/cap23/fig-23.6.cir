* Figura 23.6 (secciones 23.6 y 23.7): red de 12 V con R1 = 4 ohm en serie y R2 = 12 ohm entre a y b.
* Comprueba: V_Th = 9 V (vacío), I_N = 3 A (cortocircuito), R_Th = 9/3 = 3 ohm, y también R_Th por
* el método de la fuente de prueba (1 V entre a y b con la fuente de 12 V anulada): 1/3 A.
* Ejecutar: ngspice -b fig-23.6.cir
* red en vacío
V1  s1 0 DC 12
R11 s1 a1 4
R21 a1 0 12
* red en cortocircuito (amperímetro de 0 V entre a y b)
V2  s2 0 DC 12
R12 s2 a2 4
R22 a2 0 12
VSC a2 0 DC 0
* fuente de prueba de 1 V, con la de 12 V sustituida por un cortocircuito
R13 0 a3 4
R23 a3 0 12
VT  a3 0 DC 1
.control
op
let vth = v(a1)
let isc = i(VSC)
let rth = vth/isc
let itest = -i(VT)
let rtest = 1/itest
print vth isc rth itest rtest
.endc
.end
