* Sección 23.4, Ec. 4 (análisis de mallas): fuente de 12 V, 4 ohm propios en la malla 1,
* 8 ohm compartidos y 4 ohm propios en la malla 2.
*   Malla 1: 12 i1 - 8 i2 = 12      Malla 2: -8 i1 + 12 i2 = 0
* Comprueba: i1 = 1,8 A, i2 = 1,2 A, 0,6 A por la rama compartida, y el balance de potencias
* 21,6 W = 12,96 + 2,88 + 5,76 W.
* Ejecutar: ngspice -b mallas_23.4.cir
V1  a 0 DC 12
RA  a n 4
VI2 n p DC 0
RC  p 0 4
VIS n q DC 0
RB  q 0 8
.control
op
let i1 = -i(V1)
let i2 = i(VI2)
let icomp = i(VIS)
print i1 i2 icomp
let pfuente = 12*i1
let ptot = 4*i1^2 + 8*icomp^2 + 4*i2^2
print pfuente ptot
.endc
.end
