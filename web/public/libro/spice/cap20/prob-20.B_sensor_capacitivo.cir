* Problema 20.B (seccion 20.14): el cable se come el sensor capacitivo
* Sensor de 20 pF que pasa a 22 pF con el objeto; cable de 1 m con 100 pF en paralelo.
* Se excita con una corriente alterna de 1 uA a 10 kHz (medida de impedancia) y se compara
* la tension en el sensor con y sin objeto: la variacion relativa de capacidad aparece
* como variacion relativa de tension (V = I/(2*pi*f*C)).
* Libro: sensibilidad 10,00 % sin cable, 1,67 % con 1 m de cable (dividida por seis).
* Ejecutar:  ngspice -b prob-20.B_sensor_capacitivo.cir
* sin cable: reposo (1) y con objeto (2)
I1 0 n1 dc 0 ac 1u
C1 n1 0 20p
R1 n1 0 1G
I2 0 n2 dc 0 ac 1u
C2 n2 0 22p
R2 n2 0 1G
* con cable: reposo (3) y con objeto (4)
I3 0 n3 dc 0 ac 1u
C3 n3 0 20p
CK3 n3 0 100p
R3 n3 0 1G
I4 0 n4 dc 0 ac 1u
C4 n4 0 22p
CK4 n4 0 100p
R4 n4 0 1G
.control
ac lin 1 10k 10k
let sin_cable = (vm(n1)/vm(n2) - 1)*100
let con_cable = (vm(n3)/vm(n4) - 1)*100
let factor = sin_cable/con_cable
print sin_cable con_cable factor
echo "Libro: 10,00 % y 1,67 %, factor 6"
.endc
.end
