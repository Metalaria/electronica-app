* Problema 3.C (seccion 3.11): rizado de salida de un reductor y polarizacion DC del MLCC
* Reductor de 500 kHz que entrega 300 mA a 5 V. La bobina se sustituye por su corriente:
* un triangulo de 90 mA pico a pico (30 % de la corriente de salida) centrado en 300 mA;
* la carga es una fuente de corriente de 300 mA. El condensador se modela ideal (sin ESR ni
* ESL), como en la formula del libro dV = dI_L / (8 * f_sw * C):
*   10 uF (valor nominal)            -> 2,25 mV pico a pico
*   5 uF  (valor efectivo a 5 V)     -> 4,5 mV pico a pico, el doble
* Ejecutar:  ngspice -b prob-3.C_rizado_mlcc.cir
IL1 0 a PULSE(0.255 0.345 0 0.9999u 0.9999u 0.1n 2u)
C1 a 0 10u IC=5
ILOAD1 a 0 DC 0.3
IL2 0 b PULSE(0.255 0.345 0 0.9999u 0.9999u 0.1n 2u)
C2 b 0 5u IC=5
ILOAD2 b 0 DC 0.3
.tran 5n 100u 0 5n UIC
.control
run
meas tran rizado_10uF PP v(a) FROM=90u TO=100u
meas tran rizado_5uF PP v(b) FROM=90u TO=100u
.endc
.end
