* fig-3.9 y seccion 3.6.1 (Filtros RC), con la comprobacion numerica de la deduccion
* (Ec. 7) y el ejercicio 3.4.
* Tres filtros de primer orden excitados con 1 V de alterna:
*   - paso bajo R = 10 kohm, C = 100 nF (deduccion): fc = 159,15 Hz, -3,010 dB y -45,00 grados
*     en fc; a 1000*fc (159,15 kHz) la atenuacion es de 60 dB (tres decadas mas alla).
*   - paso bajo con C = 100 nF y R = 1,5 kohm (ejercicio 3.4, valor E12): fc = 1061 Hz.
*   - paso alto C = 100 nF, R = 1591,5 ohm (fig-3.9, fc = 1 kHz): -3 dB y +45 grados a 1 kHz;
*     a 100 Hz, -20 dB (pendiente de 20 dB/decada).
* Ejecutar:  ngspice -b fig-3.9_filtros_rc.cir
V1 in 0 DC 0 AC 1
R1 in lp 10k
C1 lp 0 100n
R2 in lp2 1.5k
C2 lp2 0 100n
C3 in hp 100n
R3 hp 0 1591.5
.ac dec 5000 1 1meg
.control
run
meas ac fc_pasobajo WHEN vdb(lp)=-3.0103
meas ac db_en_159Hz FIND vdb(lp) AT=159.155
meas ac fase_en_159Hz FIND vp(lp) AT=159.155
meas ac db_en_159kHz FIND vdb(lp) AT=159.155k
meas ac fc_ej34 WHEN vdb(lp2)=-3.0103
meas ac fc_pasoalto WHEN vdb(hp)=-3.0103
meas ac fase_pa_1kHz FIND vp(hp) AT=1k
meas ac db_pa_100Hz FIND vdb(hp) AT=100
let grados_pb = fase_en_159Hz*180/pi
let grados_pa = fase_pa_1kHz*180/pi
print grados_pb grados_pa
.endc
.end
