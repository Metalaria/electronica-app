* fig-3.8 y tabla de la seccion 3.5 (ESR y frecuencia de autorresonancia)
* Cada condensador real se modela como ESR + ESL + C en serie y se excita con una
* fuente de corriente alterna de 1 A: la tension del nodo es directamente |Z|.
* Valores del libro (tabla de la seccion 3.5 y fig-3.8):
*   electrolitico 100 uF, ESL 10 nH,  ESR 0,2 ohm  -> SRF 0,16 MHz, |Z|min ~ 0,2 ohm
*   ceramico 100 nF 0805, ESL 1,5 nH, ESR 20 mohm -> SRF 13 MHz,   |Z|min ~ 0,02 ohm
*   ceramico 100 pF 0603, ESL 0,8 nH, ESR 50 mohm -> SRF 563 MHz,  |Z|min ~ 0,05 ohm
* Tambien: |Z| del electrolitico a 1 MHz (0,21 ohm: la ESR domina, la ESL solo aporta
* 63 mohm) y a 10 MHz (0,66 ohm: ya crece con la frecuencia, se comporta como una bobina).
* Ejecutar:  ngspice -b fig-3.8_esr_autorresonancia.cir
* (el "at=" que imprime cada medida MIN es la frecuencia de autorresonancia)
I1 0 a DC 0 AC 1
Ra a a1 0.2
La a1 a2 10n
Ca a2 0 100u
I2 0 b DC 0 AC 1
Rb b b1 0.02
Lb b1 b2 1.5n
Cb b2 0 100n
I3 0 c DC 0 AC 1
Rc c c1 0.05
Lc c1 c2 0.8n
Cc c2 0 100p
.ac dec 2000 1k 2G
.control
run
meas ac zmin_electrolitico MIN vm(a) FROM=10k TO=10meg
meas ac zmin_ceramico_100n MIN vm(b) FROM=1meg TO=100meg
meas ac zmin_ceramico_100p MIN vm(c) FROM=100meg TO=2G
meas ac z_electrolitico_1MHz FIND vm(a) AT=1meg
meas ac z_electrolitico_10MHz FIND vm(a) AT=10meg
.endc
.end
