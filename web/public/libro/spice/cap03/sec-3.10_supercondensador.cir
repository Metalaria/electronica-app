* Seccion 3.10 (Supercondensadores): el calculo de "cuanto aguanta"
* Supercondensador de 1 F cargado a 2,7 V que entrega 100 mA constantes (carga de
* corriente constante, ESR despreciable). Valores del libro:
*   energia inicial 1/2*C*V^2 = 3,6 J
*   baja de 2,7 a 1,8 V en C*dV/I = 9 s
* Ejecutar:  ngspice -b sec-3.10_supercondensador.cir
C1 a 0 1 IC=2.7
I1 a 0 DC 0.1
.tran 10m 12 UIC
.control
run
meas tran t_1v8 WHEN v(a)=1.8 FALL=1
let energia_inicial = 0.5*1*2.7^2
print energia_inicial
.endc
.end
