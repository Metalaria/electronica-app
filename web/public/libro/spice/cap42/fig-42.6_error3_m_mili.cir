* cap42, seccion 42.4 «Los errores tipicos» y figura 42.6 (error 3: M es mili)
* El mismo divisor 1k / «1M» escrito mal (R3 = 1M) y bien (R4 = 1Meg).
* Con 1M ngspice entiende 1 miliohmio: la salida queda practicamente a 0 V en lugar
* de 999 mV (ngspice da 1,0 uV), y no hay ningun error ni aviso.
* Ejecutar: ngspice -b fig-42.6_error3_m_mili.cir
V1 in 0 DC 1
R1 in mal 1k
R3 mal 0 1M
R2 in bien 1k
R4 bien 0 1Meg
.control
op
print v(mal) v(bien)
.endc
.end
