* cap42, seccion 42.4 «Un ejemplo completo» y figuras 42.5 y 42.6
* El netlist del libro (filtro RC paso bajo, R1 = 1 k, C1 = 100 n) tal cual, mas
* las medidas que comprueban lo que hace: fc = 1/(2*pi*R*C) = 1591,5 Hz, -45 grados
* en fc, ganancia plana en 10 Hz y caida de 20 dB/decada (-36,0 dB en 100 kHz,
* -49,9 dB en 500 kHz).
* El analisis .ac del libro sigue siendo la linea de directiva; .meas y .print solo
* sirven para que ngspice -b imprima los resultados.
* Los avisos «can't parse 'vd'» y «'vp'» los da el preprocesado de .meas y no afectan:
* las medidas salen bien.
* Ejecutar: ngspice -b fig-42.5_filtro_rc.cir
V1 in 0 AC 1
R1 in out 1k
C1 out 0 100n
.ac dec 100 10 1Meg
.meas ac fc WHEN vdb(out)=-3.0103
.meas ac fase_fc FIND vp(out) AT=1591.55
.meas ac fase_fc_grados PARAM='fase_fc*180/3.14159265'
.meas ac g10 FIND vdb(out) AT=10
.meas ac g100k FIND vdb(out) AT=100k
.meas ac g500k FIND vdb(out) AT=500k
.print ac v(out)
.end
