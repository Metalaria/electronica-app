* cap42, seccion 42.4 «Los errores tipicos» y figura 42.6 (error 4: modelo no encontrado)
* Q1 usa el modelo 2N3904 sin .include ni .model: ngspice avisa «can't find model» y
* se detiene con «could not find a valid modelname». Este error si se ve, al contrario
* que el de las unidades (fig-42.6_error3_m_mili.cir).
* Ejecutar: ngspice -b fig-42.6_error4_modelo_no_encontrado.cir
V1 c 0 DC 5
Vb b 0 DC 0.7
Q1 c b 0 2N3904
.control
op
print i(v1)
.endc
.end
