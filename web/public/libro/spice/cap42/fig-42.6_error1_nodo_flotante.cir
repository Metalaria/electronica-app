* cap42, seccion 42.4 «Los errores tipicos», seccion 42.6 y figura 42.6 (error 1)
* Nodo flotante: x solo ve condensadores (C2 out x, C3 x 0), sin camino de continua.
* Lo que hace ngspice 42: avisa «singular matrix: check node x», fracasan el gmin
* stepping y el source stepping, y solo lo rescata su ultimo recurso («transient op»),
* que deja x en 0,5 V por el reparto capacitivo. Es el aviso de matriz singular del libro.
* La version corregida, con Rfuga x 0 1G, esta en fig-42.6_error1_rfuga.cir.
* Ejecutar: ngspice -b fig-42.6_error1_nodo_flotante.cir
V1 in 0 DC 1
R1 in out 1k
C2 out x 1n
C3 x 0 1n
.control
op
print v(out) v(x)
.endc
.end
