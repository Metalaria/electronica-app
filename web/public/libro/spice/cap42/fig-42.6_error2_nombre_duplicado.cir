* cap42, seccion 42.4 «Los errores tipicos» y figura 42.6 (error 2: nombres duplicados)
* Dos componentes con el mismo nombre (R1 dos veces): ngspice 42 NO sobrescribe en
* silencio, sino que se detiene con «device already exists, bail out».
* El caso silencioso esta en fig-42.6_error2_modelo_duplicado.cir.
* Ejecutar: ngspice -b fig-42.6_error2_nombre_duplicado.cir
V1 in 0 DC 1
R1 in out 1k
R1 out 0 10k
.control
op
print v(out)
.endc
.end
