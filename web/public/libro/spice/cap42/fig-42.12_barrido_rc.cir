* cap42, seccion 42.9 y figura 42.12 (panel izquierdo): barrido parametrico de R
* Filtro RC paso bajo con C = 10 nF y R = 1k, 2k2, 4k7, 10k y 22k. La figura marca el
* punto de -3 dB de cada curva: fc = 1/(2*pi*R*C) = 15,9 kHz, 7,23 kHz, 3,39 kHz,
* 1,59 kHz y 723 Hz. ngspice no tiene .step: el barrido se hace con foreach y alter.
* Ejecutar: ngspice -b fig-42.12_barrido_rc.cir
V1 in 0 DC 0 AC 1
R1 in out 1k
C1 out 0 10n
.control
foreach rval 1k 2.2k 4.7k 10k 22k
  alter r1 = $rval
  ac dec 200 10 1Meg
  meas ac fc WHEN vdb(out)=-3.0103
  echo R = $rval
end
.endc
.end
