* cap42, figuras 42.2 y 42.3 (columna «DC operating point» / «.op»)
* Las figuras dan como ejemplo V(b) = 2,1 V, V(c) = 6,3 V, IC = 1,2 mA (42.3) y
* V(b) = 1,8 V, V(out) = 6,2 V, I(Q1) = 1,1 mA (42.2). Este emisor comun con valores
* normalizados (12 V, divisor 47k/10k, RC = 4k7, RE = 1k2) da del orden de los de la
* figura 42.3; con divisor 56k/10k y RC = 5k1, RE = 1k, los de la 42.2. Solo comprueba
* que los valores de ejemplo son coherentes con un circuito real. ngspice 42 da
* V(b) = 2,04 V, V(c) = 6,66 V, IC = 1,14 mA (primer circuito) y V(b) = 1,75 V,
* V(c) = 6,49 V, IC = 1,08 mA (segundo).
* Ejecutar: ngspice -b fig-42.3_op_emisor_comun.cir
.model Q2N3904 NPN(IS=6.734f XTI=3 EG=1.11 VAF=74.03 BF=416.4 NE=1.259 ISE=6.734f
+ IKF=66.78m XTB=1.5 BR=.7371 NC=2 ISC=0 IKR=0 RC=1 CJC=3.638p MJC=.3085 VJC=.75 FC=.5
+ CJE=4.493p MJE=.2593 VJE=.75 TR=239.5n TF=301.2p ITF=.4 VTF=4 XTF=2 RB=10)
Vcc vcc 0 DC 12
* example of figure 42.3
R1 vcc b 47k
R2 b 0 10k
RC vcc c 4.7k
RE e 0 1.2k
Q1 c b e Q2N3904
* example of figure 42.2
R3 vcc b2 56k
R4 b2 0 10k
RC2 vcc c2 5.1k
RE2 e2 0 1k
Q2 c2 b2 e2 Q2N3904
.control
op
print v(b) v(c) v(e) (v(vcc)-v(c))/4.7k
print v(b2) v(c2) v(e2) (v(vcc)-v(c2))/5.1k
.endc
.end
