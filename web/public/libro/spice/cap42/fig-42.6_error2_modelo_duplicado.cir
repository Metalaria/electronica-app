* cap42, seccion 42.4 «Los errores tipicos» (nombres duplicados que no dan error)
* Dos .model con el mismo nombre, como ocurre al incluir dos bibliotecas que traen el
* mismo diodo: ngspice 42 no da error ni aviso y usa la primera definicion (IS = 1e-14):
* v(k) = 0,629 V. Con la segunda (IS = 1e-9) seria 0,346 V. (Un .subckt repetido, en
* cambio, si da un aviso: «redefinition of .subckt ..., ignored».)
* Ejecutar: ngspice -b fig-42.6_error2_modelo_duplicado.cir
V1 a 0 DC 1
R1 a k 1k
D1 k 0 DX
.model DX D(IS=1e-14)
.model DX D(IS=1e-9)
.control
op
print v(k)
.endc
.end
