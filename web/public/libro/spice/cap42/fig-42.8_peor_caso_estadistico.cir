* cap42, seccion 42.5 «La suma en cuadratura, sin simular» y figura 42.8
* Un resultado que depende con sensibilidad unidad de cada componente: una cadena de
* diez etapas en las que cada una multiplica por Rk/1k (transconductancia de 1 mS sobre
* Rk). Cada Rk es una resistencia del 1 % gaussiana con la tolerancia a 3 sigma.
* Se mide la desviacion de v(n6) (seis componentes, figura 42.8) y de v(n10) (diez,
* texto de la seccion 42.5):
*   peor caso (todas al +1 %): 1,01^6 - 1 = 6,2 %   y   1,01^10 - 1 = 10,5 %
*   estadistico (3 sigma):     1 % * sqrt(6) = 2,4 %   y   1 % * sqrt(10) = 3,2 %
* ngspice 42: peor caso 6,15 % y 10,46 %; 3 sigma de 3000 muestras 2,49 % y 3,19 %.
* Ejecutar: ngspice -b fig-42.8_peor_caso_estadistico.cir  (unos segundos)
V0 n0 0 DC 1
G1 0 n1 n0 0 1m
R1 n1 0 1k
G2 0 n2 n1 0 1m
R2 n2 0 1k
G3 0 n3 n2 0 1m
R3 n3 0 1k
G4 0 n4 n3 0 1m
R4 n4 0 1k
G5 0 n5 n4 0 1m
R5 n5 0 1k
G6 0 n6 n5 0 1m
R6 n6 0 1k
G7 0 n7 n6 0 1m
R7 n7 0 1k
G8 0 n8 n7 0 1m
R8 n8 0 1k
G9 0 n9 n8 0 1m
R9 n9 0 1k
G10 0 n10 n9 0 1m
R10 n10 0 1k
.control
* worst case: all resistors at +1 %
foreach r r1 r2 r3 r4 r5 r6 r7 r8 r9 r10
  alter $r = 1.01k
end
op
let pc6 = 100*(v(n6) - 1)
let pc10 = 100*(v(n10) - 1)
print pc6 pc10
destroy
* Monte Carlo: Gaussian, sigma = 1/3 %
set n = 3000
let d6 = vector($n)
let d10 = vector($n)
let k = 0
setseed 7
repeat $n
  foreach r r1 r2 r3 r4 r5 r6 r7 r8 r9 r10
    let rv = 1k*(1 + sgauss(0)/300)
    alter $r = rv
  end
  op
  let d6[k] = 100*(v(n6) - 1)
  let d10[k] = 100*(v(n10) - 1)
  destroy
  let k = k + 1
end
let s3_6 = 3*sqrt(mean((d6 - mean(d6))^2))
let s3_10 = 3*sqrt(mean((d10 - mean(d10))^2))
print s3_6 s3_10
print maximum(abs(d10))
.endc
.end
