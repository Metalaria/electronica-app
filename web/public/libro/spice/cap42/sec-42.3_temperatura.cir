* cap42, seccion 42.3 «La temperatura y el ruido» (y seccion 42.9, barrido de temperatura)
* Un diodo descrito solo con IS y N (sin XTI, EG ni coeficientes termicos escritos) y una
* fuente de comportamiento B (salida = 2 x entrada) simulados a 25 y a 125 grados.
* El diodo SI cambia: SPICE aplica a los primitivos de semiconductor la tension termica
* kT/q y los valores por defecto de EG y XTI, y v(k) baja de 0,589 V a 0,388 V
* (-2 mV/grado). La fuente B, como cualquier macromodelo hecho de fuentes controladas y
* resistencias sin coeficiente, da 10,000 V en ambos casos.
* Ejecutar: ngspice -b sec-42.3_temperatura.cir
V1 a 0 DC 5
R1 a k 4.3k
D1 k 0 DX
.model DX D(IS=2.52n N=1.752)
B1 o 0 V=2*v(a)
R2 o 0 1k
.control
set temp=25
op
print v(k) v(o)
set temp=125
op
print v(k) v(o)
.endc
.end
