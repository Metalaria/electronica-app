* cap42, seccion 42.4 «Los errores tipicos», seccion 42.6 y figura 42.6 (error 1, corregido)
* El mismo circuito con la resistencia de fuga de 1 Gohm que propone el libro: el punto
* de trabajo se resuelve a la primera, sin avisos, y v(out) no cambia (1 V).
* Ejecutar: ngspice -b fig-42.6_error1_rfuga.cir
V1 in 0 DC 1
R1 in out 1k
C2 out x 1n
C3 x 0 1n
Rfuga x 0 1G
.control
op
print v(out) v(x)
.endc
.end
