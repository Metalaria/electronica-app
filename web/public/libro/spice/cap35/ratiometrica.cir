* Secciones 35.3 y 35.10, figura 35.16: medida ratiométrica de un puente completo de 350 Ohm a
* 1000 microdeformaciones (GF = 2; 10 mV con 5 V), amplificado 250 veces (2,5 V con 5 V de excitación)
* y leído por un ADC de 16 bits modelado como código = Vseñal/Vref * 2^16.
* Barrido de la excitación de 4,75 a 5,25 V (la prueba del banco de ±5 %):
*   - con referencia fija de 5 V el código sigue a la excitación (±5 %);
*   - con la referencia tomada de la propia excitación el código no cambia (32768).
* Ejecutar: ngspice -b ratiometrica.cir
.param R=350 dR=0.7
VEXC exc 0 DC 5
RF1 exc fl {R+dR}
RF2 fl 0 {R-dR}
RF3 exc fr {R-dR}
RF4 fr 0 {R+dR}
* amplificador de instrumentación ideal, ganancia 250
EA amp 0 fr fl 250
VREF ref 0 DC 5
BFIJA cfija 0 V=V(amp)/V(ref)*65536
BRAT crat 0 V=V(amp)/V(exc)*65536
.control
  dc VEXC 4.75 5.25 0.25
  echo "Excitación, código con referencia fija y código ratiométrico:"
  print v(exc) v(cfija) v(crat)
.endc
.end
