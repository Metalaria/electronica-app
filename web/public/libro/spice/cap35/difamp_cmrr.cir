* Sección 35.7 y figura 35.13: amplificador diferencial de un operacional y cuatro resistencias de
* 10 kOhm, ganancia unidad, con el peor reparto de tolerancias del 1 % (R1 y R4 a +1 %, R2 y R3 a -1 %).
* Comprueba: un voltio de modo común produce unos 20 mV a la salida (CMRR de 34 dB); con resistencias
* del 0,01 % el error baja a 0,2 mV (74 dB).
* Operacional: VCVS de ganancia 1e5 (el polo no influye en continua).
* Ejecutar: ngspice -b difamp_cmrr.cir
.param R=10k t=0.01 t2=0.0001
VCM cm 0 DC 1
* tolerancia 1 %
R1 cm n {R*(1+t)}
R2 n out {R*(1-t)}
R3 cm p {R*(1-t)}
R4 p 0 {R*(1+t)}
E1 out 0 p n 1e5
* tolerancia 0,01 %
R1b cm nb {R*(1+t2)}
R2b nb outb {R*(1-t2)}
R3b cm pb {R*(1-t2)}
R4b pb 0 {R*(1+t2)}
E2 outb 0 pb nb 1e5
.control
  op
  echo "Salida con 1 V de modo común (mV), 1 % y 0,01 % (unos 20 y 0,2):"
  print v(out)*1000 v(outb)*1000
  echo "CMRR (dB) con ganancia diferencial unidad (unos 34 y 74):"
  print 20*log10(1/abs(v(out))) 20*log10(1/abs(v(outb)))
.endc
.end
