* Capítulo 18, problema 18.C: mantener un equipo de 2,5 W durante el apagado ordenado con un
* condensador cargado a 5 V, hasta que la tensión baja a 4,5 V.
* La carga es de potencia constante (I = P/V), como la de un convertidor conmutado.
* Comprueba (tiempo hasta 4,5 V):
*   - 53 mF  -> ~50 ms;
*   - 211 mF -> ~200 ms;
*   - 12 x 4700 uF = 56,4 mF -> algo más de 50 ms (11 x 4700 uF = 51,7 mF se queda corto);
*   - 1 F (supercondensador) -> ~0,95 s.
* Ejecutar: ngspice -b prob-18.C.cir
.param p=2.5
C1 v1 0 53m IC=5
B1 v1 0 I={p}/max(V(v1),0.5)
C2 v2 0 211m IC=5
B2 v2 0 I={p}/max(V(v2),0.5)
C3 v3 0 51.7m IC=5
B3 v3 0 I={p}/max(V(v3),0.5)
C4 v4 0 56.4m IC=5
B4 v4 0 I={p}/max(V(v4),0.5)
C5 v5 0 1 IC=5
B5 v5 0 I={p}/max(V(v5),0.5)
.tran 1m 1.2 uic
.meas tran t53m  WHEN v(v1)=4.5 FALL=1
.meas tran t211m WHEN v(v2)=4.5 FALL=1
.meas tran t11x  WHEN v(v3)=4.5 FALL=1
.meas tran t12x  WHEN v(v4)=4.5 FALL=1
.meas tran t1F   WHEN v(v5)=4.5 FALL=1
.end
