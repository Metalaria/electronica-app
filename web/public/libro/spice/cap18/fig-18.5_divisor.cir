* Capítulo 18, figura 18.5 y solución del ejercicio 18.2: divisor resistivo para llevar una
* salida de 5 V a un GPIO de 3,3 V.
* Comprueba:
*   - figura 18.5: 2,2 k / 3,3 k -> 3,0 V en el GPIO;
*   - ejercicio 18.2: 1 k / 2 k -> 3,33 V;
*   - la carga del propio GPIO (fuga de entrada, < 10 uA) no cambia esas cifras.
* Ejecutar: ngspice -b fig-18.5_divisor.cir
V5 s 0 DC 5
RA1 s n1 2.2k
RB1 n1 0 3.3k
IL1 n1 0 DC 10u
RA2 s n2 1k
RB2 n2 0 2k
IL2 n2 0 DC 10u
.control
op
echo "2,2 k / 3,3 k y 1 k / 2 k (con 10 uA de fuga en el GPIO):"
print v(n1) v(n2)
.endc
.end
