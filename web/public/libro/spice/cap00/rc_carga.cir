* Carga de un RC desde una fuente de tension: dos ejemplos del capitulo 0.
* (a) Ejercicio ej-0.6: R = 10 kohm, C = 4,7 uF, hacia 5 V. Libro: tau = 47 ms y
*     v(tau) = 5*(1 - e^-1) = 3,16 V.
* (b) Seccion 0.10 (escalon del RC por Laplace) y figura fig-0.11: escalon unidad, RC = 1 ms.
*     Libro: 1 - e^(-t/RC), 63 % en t = RC; tabla de la seccion 0.4: 86,5 % a 2 tau,
*     95,0 % a 3 tau, 99,3 % a 5 tau; mitad del valor final a 0,693 tau.
* Ejecutar:  ngspice -b rc_carga.cir
Va ina 0 PWL(0 0 1n 5)
Ra ina a 10k
Ca a 0 4.7u
Vb inb 0 PWL(0 0 1n 1)
Rb inb b 1k
Cb b 0 1u
.tran 10u 250m
.meas tran va_tau  FIND v(a) AT=47m
.meas tran vb_1tau FIND v(b) AT=1m
.meas tran vb_2tau FIND v(b) AT=2m
.meas tran vb_3tau FIND v(b) AT=3m
.meas tran vb_5tau FIND v(b) AT=5m
.meas tran tb_mitad WHEN v(b)=0.5 RISE=1
.end
