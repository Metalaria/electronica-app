* Seccion 0.8 (Ecuaciones diferenciales: primer orden) y figura fig-0.9 (panel izquierdo)
* Condensador cargado a V0 = 5 V que se descarga por una resistencia, RC = 1 ms
* (R = 1 kohm, C = 1 uF). El libro: a los 2 ms quedan 5*e^-2 = 0,677 V.
* Ejecutar:  ngspice -b rc_descarga.cir
R1 a 0 1k
C1 a 0 1u IC=5
.tran 1u 5m UIC
.meas tran v_1ms FIND v(a) AT=1m
.meas tran v_2ms FIND v(a) AT=2m
.end
