* The same two-stage ladder fed directly by the step (no parasitic), same analysis
V1 in 0 1
R1 in 1 10k
C1 1 0 1u
R2 1 2 10k
C2 2 0 1u
.tran 0.1m 100m uic
.end
