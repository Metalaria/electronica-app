* Three-stage RC ladder (R = 10k, C = 1u): step of 1 V from rest
V1 in 0 1
R1 in 1 10k
C1 1 0 1u
R2 1 2 10k
C2 2 0 1u
R3 2 3 10k
C3 3 0 1u
.options reltol=1e-6 abstol=1e-15 vntol=1e-9
.tran 0.05m 200m 0 0.05m uic
.end
