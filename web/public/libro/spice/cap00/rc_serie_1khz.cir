* Seccion 0.9 (Impedancia compleja y analisis fasorial), ejemplo del RC serie a 1 kHz
* (es tambien la figura fig-0.10, que se publica en la seccion 24.4).
* R = 1 kohm y C = 100 nF en serie, 1 V eficaz a 1 kHz. El libro da:
*   Z_C = -j*1592 ohm, |Z| = 1880 ohm, angulo de Z = -57,9 grados,
*   I = 0,532 mA adelantada 57,9 grados respecto a la tension,
*   V_R = 0,532 V, V_C = 0,847 V (0,532 + 0,847 = 1,38 V, pero los fasores suman 1 V).
* Ejecutar:  ngspice -b rc_serie_1khz.cir
V1 in 0 DC 0 AC 1
R1 in m 1k
C1 m 0 100n
.control
ac lin 1 1k 1k
* barrido AC de un solo punto; resultados con let/print (zmod en ohm, fases en grados, VR y VC en V)
* i(V1) sale de la fuente con signo SPICE (entra por el terminal +): la corriente del circuito es -i(V1)
let icirc = -i(V1)
let zmod = 1/mag(icirc)
let zfase = -180/pi*cph(icirc)
let ifase = 180/pi*cph(icirc)
print zmod zfase ifase
print mag(v(in,m)) mag(v(m))
.endc
.end
