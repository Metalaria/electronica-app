* Seccion 0.8 (Ecuaciones diferenciales: segundo orden) y figura fig-0.9 (panel derecho)
* RLC serie con R = 10 ohm, L = 1 mH, C = 1 uF; el condensador parte cargado a 1 V
* y se descarga por la bobina y la resistencia (respuesta natural).
* El libro: w0 = 31 623 rad/s (f0 = 5,03 kHz), zeta = (R/2)*sqrt(C/L) = 0,158,
* subamortiguado; oscila a w0*sqrt(1 - zeta^2), es decir, a 4,97 kHz.
* Aqui se mide el periodo entre dos maximos de la tension del condensador y la
* relacion entre dos maximos consecutivos, que debe ser exp(-2*pi*zeta/sqrt(1-zeta^2)) = 0,366.
* Ejecutar:  ngspice -b rlc_serie_subamortiguado.cir
C1 a 0 1u IC=1
L1 a b 1m IC=0
R1 b 0 10
.tran 0.1u 2m UIC
.meas tran t1 WHEN v(a)=0 FALL=1
.meas tran t3 WHEN v(a)=0 FALL=2
.meas tran periodo PARAM='t3-t1'
.meas tran fd PARAM='1/(t3-t1)'
.meas tran vmin1 MIN v(a) FROM=0 TO=0.2m
.meas tran vmin2 MIN v(a) FROM=0.2m TO=0.4m
.meas tran razon PARAM='vmin2/vmin1'
.end
