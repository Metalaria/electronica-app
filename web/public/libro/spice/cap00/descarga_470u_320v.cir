* Seccion 0.4 (Exponenciales y logaritmos), ejemplo tomado de la seccion 53.2:
* un condensador de 470 uF cargado a 320 V se descarga por 1 kohm (tau = 0,47 s).
* El libro: baja de 30 V en t = tau*ln(320/30) = 2,4 tau = 1,11 s.
* Ejecutar:  ngspice -b descarga_470u_320v.cir
R1 a 0 1k
C1 a 0 470u IC=320
.tran 1m 3 UIC
.meas tran t30 WHEN v(a)=30 FALL=1
.meas tran t30_en_tau PARAM='t30/0.47'
.end
