* The same RLC with -15 ohm in series (total -5 ohm): the oscillation grows from 1 mV
R1 1 2 10
Rneg 2 4 -15
L1 4 3 1m ic=0
C1 3 1 1u ic=1m
Rref 1 0 1G
.options reltol=1e-6 abstol=1e-15 vntol=1e-9
.tran 0.1u 1m 0 0.1u uic
.end
