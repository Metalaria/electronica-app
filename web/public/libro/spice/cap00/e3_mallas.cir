* Exercise: three meshes. V1 = 12 V, R1 2k, R2 4k (shared 1-2), R3 2k, R4 4k (shared 2-3), R5 2k, V2 = 6 V
V1 in 0 12
R1 in a 2k
R2 a 0 4k
R3 a b 2k
R4 b 0 4k
R5 b c 2k
V2 c 0 6
.op
.end
