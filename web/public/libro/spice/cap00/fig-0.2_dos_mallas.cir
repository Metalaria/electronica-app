* fig-0.2 / seccion 0.2 (Algebra esencial: sistemas de ecuaciones con un circuito) y seccion 0.12 (Cramer)
* Dos mallas: fuente de 12 V (+ arriba), 4 ohm en la malla 1, 6 ohm compartida, 3 ohm en la malla 2.
* El libro resuelve 10*I1 - 6*I2 = 12 y -6*I1 + 9*I2 = 0 y obtiene:
*   I1 = 2 A, I2 = 1,333 A, corriente por la resistencia compartida I1 - I2 = 0,667 A.
* Comprobacion de energia (recuadro de la deduccion): la fuente entrega 24 W y las
* resistencias disipan 16 W + 5,33 W + 2,67 W = 24 W.
* Ejecutar:  ngspice -b fig-0.2_dos_mallas.cir
V1 n1 0 DC 12
R4 n1 n2 4
R6 n2 0 6
R3 n2 n3 3
* amperimetro de 0 V en la rama de la derecha para leer I2
VI2 n3 0 DC 0
.control
op
let i1 = -i(V1)
let i2 = i(VI2)
let i6 = v(n2)/6
print i1 i2 i6
let pfuente = 12*i1
let p4 = 4*i1*i1
let p3 = 3*i2*i2
let p6 = 6*i6*i6
let psuma = p4 + p3 + p6
print pfuente p4 p3 p6 psuma
.endc
.end
