* Seccion 0.6 (Calculo diferencial) y ejercicio ej-0.4: i = C*dv/dt y v = L*di/dt con numeros.
* (a) 100 nF con una tension que sube a 1000 V/s: el libro da 100 uA.
* (b) ej-0.4: 10 uF con 2 V en 1 ms (2000 V/s): 20 mA.
* (c) Flanco de 3,3 V en 2 ns sobre 10 pF parasitos: 1,65 V/ns y 16,5 mA.
* (d) 10 mH con una corriente que cambia 1 A en 1 ms: 10 V.
* (e) La misma bobina si se corta 1 A en 1 us: 10 000 V.
* Las rampas son fuentes PWL; las corrientes se leen en las propias fuentes de tension.
* Ejecutar:  ngspice -b derivadas_c_l.cir
Va a 0 PWL(0 0 1m 1)
Ca a 0 100n
Vb b 0 PWL(0 0 1m 2)
Cb b 0 10u
Vc c 0 PWL(0 0 2n 3.3)
Cc c 0 10p
Id 0 d PWL(0 0 1m 1)
Ld d 0 10m
Ie 0 e PWL(0 1 1u 0)
Le e 0 10m IC=1
* output step 1 us: the PWL corners (2 ns, 1 us) are breakpoints, so the fast edges are still
* resolved exactly; a 0,1 ns step stored 12 million points (38 s and 560 MB)
.tran 1u 1.2m UIC
.meas tran ia FIND i(Va) AT=0.5m
.meas tran ib FIND i(Vb) AT=0.5m
.meas tran ic FIND i(Vc) AT=1n
.meas tran vd FIND v(d) AT=0.5m
.meas tran ve FIND v(e) AT=0.5u
.end
