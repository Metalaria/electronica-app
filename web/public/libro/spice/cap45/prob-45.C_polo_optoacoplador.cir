* Capitulo 45, problema 45.C «Un optoacoplador dentro de un lazo de realimentacion»
* Polo de salida del optoacoplador: la capacidad parasita de salida del fototransistor (la capacidad
* colector-base multiplicada por el efecto Miller, del orden de 1 a 3 nF en un optoacoplador comun;
* aqui 2 nF) con la resistencia de carga. Se modela la salida como una fuente de corriente
* (la fotocorriente de colector) que carga R_L en paralelo con C.
* Resultados esperados: polo (-3 dB) en 7,96 kHz con 10 kohm y en 79,6 kHz con 1 kohm.
* Tambien imprime la dispersion de CTR 300 % / 50 % = 6 -> 15,6 dB.
* Ejecutar: ngspice -b prob-45.C_polo_optoacoplador.cir
I10 0 o10 DC 0 AC 1m
RL10 o10 0 10k
C10 o10 0 2n

I1 0 o1 DC 0 AC 1m
RL1 o1 0 1k
C1 o1 0 2n

.ac dec 200 100 10meg
.control
run
let g10 = vdb(o10)
let g1 = vdb(o1)
meas ac ref10 find g10 at=100
meas ac ref1 find g1 at=100
let t10 = ref10 - 3.0103
let t1 = ref1 - 3.0103
meas ac fpolo_10k when g10=t10
meas ac fpolo_1k when g1=t1
let disp_db = 20*log10(300/50)
print disp_db
.endc
.end
