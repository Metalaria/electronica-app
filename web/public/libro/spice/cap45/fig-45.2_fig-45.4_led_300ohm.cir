* Capitulo 45, figuras 45.2 y 45.4 (seccion 45.2) y ejercicio 45.1
* LED alimentado desde 5 V a traves de una resistencia serie de 300 ohm: V_f = 2 V, I = 10 mA.
* El LED se modela con una exponencial de Shockley con n*V_T = 52 mV (N = 2,01 a 27 grados) y una
* I_S ajustada para que pase exactamente por (2,0 V; 10 mA), igual que el guion de la figura 45.4.
* Comprueba:
*   - figura 45.2: punto de trabajo 2,0 V y 10 mA con 5 V y 300 ohm;
*   - figura 45.4: con 5,5 V (+10 %) la corriente sube solo a unos 11,6 mA (+16 %), mientras que
*     sin resistencia, 2,1 V aplicados al LED dan unos 68 mA (x6,8);
*   - ejercicio 45.1: con el valor normalizado de 330 ohm la corriente baja a unos 9 mA.
* Ejecutar: ngspice -b fig-45.2_fig-45.4_led_300ohm.cir
.model LEDR D(IS=1.9786e-19 N=2.01044)

* figura 45.2: 5 V, 300 ohm
V1 v1 0 DC 5
R1 v1 a1 300
D1 a1 0 LEDR

* figura 45.4: misma resistencia con 5,5 V
V2 v2 0 DC 5.5
R2 v2 a2 300
D2 a2 0 LEDR

* figura 45.4: LED sin resistencia, con 2,1 V directamente en sus bornes
V3 a3 0 DC 2.1
D3 a3 0 LEDR

* ejercicio 45.1: 330 ohm normalizado
V4 v4 0 DC 5
R4 v4 a4 330
D4 a4 0 LEDR

.control
op
let i_5v = (v(v1)-v(a1))/300
let i_55v = (v(v2)-v(a2))/300
let i_noR = -i(V3)
let i_330 = (v(v4)-v(a4))/330
print v(a1) i_5v
print v(a2) i_55v
print i_noR
print v(a4) i_330
.endc
.end
