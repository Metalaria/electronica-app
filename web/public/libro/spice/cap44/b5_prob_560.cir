* P13: problem 43.D: same, bias 560 ohm
VCC vcc 0 DC 5.0
VR vr 0 DC 2.5
RUP vcc b 560
RDN a 0 560
RT1 b a 120
RT2 b a 120
RUA a vr 459.33
RUB b vr 459.33
.op
.end
