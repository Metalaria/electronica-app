* P13: bias 680 ohm, two 120 ohm terminations, no unit loads (book problem 43.B)
VCC vcc 0 DC 5.0
VR vr 0 DC 2.5
RUP vcc b 680
RDN a 0 680
RT1 b a 120
RT2 b a 120
.op
.end
