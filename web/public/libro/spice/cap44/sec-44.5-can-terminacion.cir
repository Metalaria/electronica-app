* Sección 44.5 («En el banco») y sección 44.10: medida de la terminación de un bus CAN (o RS-485)
* con el bus sin alimentar. El polímetro se modela como una corriente de prueba de 1 mA entre CAN_H
* y CAN_L; la tensión que aparece, dividida por 1 mA, es la resistencia que leería.
* Tres casos: dos terminaciones de 120 Ohm (correcto), una sola (falta una) y tres (sobra una).
* Comprueba: 60 Ohm, 120 Ohm y 40 Ohm, como dice el texto.
* Ejecutar: ngspice -b sec-44.5-can-terminacion.cir
* two terminations (correct)
I2 0 h2 1m
R2a h2 0 120
R2b h2 0 120
* only one termination
I1 0 h1 1m
R1a h1 0 120
* three terminations
I3 0 h3 1m
R3a h3 0 120
R3b h3 0 120
R3c h3 0 120
.control
  op
  echo "Resistencia CAN_H-CAN_L en ohmios: dos terminaciones (60), una (120), tres (40):"
  print v(h2)/1m v(h1)/1m v(h3)/1m
.endc
.end
