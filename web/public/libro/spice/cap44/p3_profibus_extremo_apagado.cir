* P13: PROFIBUS segment, one end unpowered (VP2 = 0 V), 32 unit loads
VP vp 0 DC 5
VR vr 0 DC 2.5
RU1 vp b 390
RM1 b a 220
RD1 a 0 390
RU2 0 b 390
RM2 b a 220
RD2 a 0 390
RUA a vr 375
RUB b vr 375
.op
.end
