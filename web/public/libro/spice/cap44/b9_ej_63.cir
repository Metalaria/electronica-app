* P13: exercise: 63 nodes at 1/4 UL + master 1 UL, bias 560 ohm
VCC vcc 0 DC 5.0
VR vr 0 DC 2.5
RUP vcc b 560
RDN a 0 560
RT1 b a 120
RT2 b a 120
RUA a vr 716.418
RUB b vr 716.418
.op
.end
