* P13: bias 680 ohm, terminations, 32 unit loads, VR = 2.5 V
VCC vcc 0 DC 5.0
VR vr 0 DC 2.5
RUP vcc b 680
RDN a 0 680
RT1 b a 120
RT2 b a 120
RUA a vr 375
RUB b vr 375
.op
.end
