* Figura 25.10 y seccion 25.6: el condensador conmutado como resistencia, R_eq = 1/(C f).
* C = 1 pF conmutado entre V1 = 1 V y V2 = 0 V por dos fases sin solape a f = 100 kHz.
* El libro da R_eq = 10 Mohm, es decir, una corriente media de 1 V / 10 Mohm = 100 nA.
* Interruptores SW (Ron = 100 ohm, Roff = 1e12 ohm); fase 1 de 0 a 4,5 us, fase 2 de 5 a 9,5 us.
* Se mide la corriente media que entrega V1 en 50 periodos tras el arranque y la R_eq = 1 V / I.
* Ejecutar:  ngspice -b fig-25.10.cir
* Resultado (ngspice-42): corriente media 99,93 nA, R_eq = 10,007 Mohm (el libro: 10 Mohm).
V1 v1 0 DC 1
V2 v2 0 DC 0
Vp1 p1 0 PULSE(0 1 0 10n 10n 4.48u 10u)
Vp2 p2 0 PULSE(0 1 5u 10n 10n 4.48u 10u)
S1 v1 c p1 0 sw
S2 c v2 p2 0 sw
C c 0 1p
.model sw SW(Vt=0.5 Vh=0 Ron=100 Roff=1e12)
.tran 1n 600u 0 5n
.meas tran i_media AVG i(V1) FROM=100u TO=600u
.meas tran r_eq PARAM='-1/i_media'
.end
