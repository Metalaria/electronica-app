* Figuras 25.3 y 25.4 (seccion 25.3): un polo real, paso bajo RC con f_p = 1 kHz.
* R = 1,5915 kohm y C = 100 nF dan f_p = 1/(2 pi R C) = 1,000 kHz.
* El texto da: -3 dB y -45 grados en el polo; error de la asintota de -1 dB a una octava
* (500 Hz y 2 kHz) y de -0,3 dB a dos octavas (250 Hz y 4 kHz); fase de -5,7 grados una
* decada antes (100 Hz) y de -84 grados una decada despues (10 kHz); -20 dB/decada lejos del polo.
* Asintota: 0 dB por debajo de f_p y -20 log(f/f_p) por encima (-6,02 dB a 2 kHz, -12,04 dB a 4 kHz).
* Fase en grados con cph (fase continua). Ejecutar:  ngspice -b fig-25.4.cir
* Resultado (ngspice-42): -3,01 dB y -45,0 grados en 1 kHz; -0,97 dB a 500 Hz y error -0,97 dB a 2 kHz;
* -0,26 dB a 250 Hz y error -0,26 dB a 4 kHz; -5,71 grados a 100 Hz, -84,3 grados a 10 kHz; -19,96 dB/dec.
Vin in 0 DC 0 AC 1
R1 in out 1.5915k
C1 out 0 100n
.control
ac dec 400 10 1meg
let gdb_out = db(v(out))
let fase_out = 180/pi*cph(v(out))
meas ac g_polo FIND gdb_out AT=1k
meas ac fase_polo FIND fase_out AT=1k
meas ac g_500 FIND gdb_out AT=500
meas ac g_2k FIND gdb_out AT=2k
let err_2k = g_2k+6.0206
echo "err_2k = $&err_2k"
meas ac g_250 FIND gdb_out AT=250
meas ac g_4k FIND gdb_out AT=4k
let err_4k = g_4k+12.0412
echo "err_4k = $&err_4k"
meas ac fase_100 FIND fase_out AT=100
meas ac fase_10k FIND fase_out AT=10k
meas ac g_10k FIND gdb_out AT=10k
meas ac g_100k FIND gdb_out AT=100k
let pendiente = g_100k-g_10k
echo "pendiente = $&pendiente"
.endc
.end
