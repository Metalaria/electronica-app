* Sección 16.5 («Los tres componentes externos que importan») y figura 16.5: corte inferior del
* condensador de acoplo de salida de un amplificador de alimentación simple con el altavoz.
* El libro da 42 Hz para 470 µF con 8 Ohm. En el FM7303 los condensadores de salida del TEA2025 son
* C53 y C58 de 1000 µF (esquema del kit): 20 Hz con 8 Ohm y 40 Hz con 4 Ohm.
* La salida del integrado se modela como fuente de tensión ideal (impedancia de salida despreciable).
* Ejecutar: ngspice -b sec-16.5_acoplo_salida.cir
V1 a 0 AC 1
C470 a s1 470u
RL1  s1 0 8
C1k8 a s2 1000u
RL2  s2 0 8
C1k4 a s3 1000u
RL3  s3 0 4
.control
  ac dec 2000 1 1k
  meas ac fc_470u_8ohm  when vdb(s1)=-3.0103 rise=1
  meas ac fc_1000u_8ohm when vdb(s2)=-3.0103 rise=1
  meas ac fc_1000u_4ohm when vdb(s3)=-3.0103 rise=1
  echo "Esperado: 42,3 Hz; 19,9 Hz; 39,8 Hz"
.endc
.end
