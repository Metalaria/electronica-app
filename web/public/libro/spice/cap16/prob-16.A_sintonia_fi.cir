* Problema 16.A (sección 16.23) y tarjeta de la sección 16.22: sensibilidad del ajuste de un circuito
* sintonizado de FI y resonancia de las bobinas reales del kit.
* Qué muestra: cuatro tanques LC en paralelo, C = 220 pF y L = 1 µH con +0 %, +1 %, +5 % y +10 %
* (el núcleo roscado cambia L); el libro da 10,730 MHz y desplazamientos de -53,3 / -258,6 / -499,4 kHz.
* Además, el transformador de FI B1 del FM7303 (primario 3 µH con C13 = 75 pF en paralelo, según el
* esquema del kit) y la bobina del discriminador B2 (7,6 µH con C27 = 24 pF): B1 debe resonar cerca de
* 10,7 MHz; B2, con solo 24 pF, queda por encima (unos 11,8 MHz) y llega a 10,7 MHz con unos 5 pF más de
* capacidades parásitas y del integrado y con el ajuste del núcleo.
* Cada tanque se excita con una fuente de corriente de 1 mA y una resistencia de 20 kOhm fija un Q finito.
* Ejecutar: ngspice -b prob-16.A_sintonia_fi.cir   (las frecuencias salen en los "at=" de cada .meas)
I0  0 t0  AC 1m
L0  t0 0 1u
C0  t0 0 220p
R0  t0 0 20k
I1  0 t1  AC 1m
L1  t1 0 1.01u
C1  t1 0 220p
R1  t1 0 20k
I5  0 t5  AC 1m
L5  t5 0 1.05u
C5  t5 0 220p
R5  t5 0 20k
I10 0 t10 AC 1m
L10 t10 0 1.10u
C10 t10 0 220p
R10 t10 0 20k
* B1 del kit: primario 1-3, 11 espiras, 3 µH, con C13 = 75 pF
IB1 0 b1 AC 1m
LB1 b1 0 3u
CB1 b1 0 75p
RB1 b1 0 20k
* B2 del kit: 18 espiras, 7,6 µH, con C27 = 24 pF
IB2 0 b2 AC 1m
LB2 b2 0 7.6u
CB2 b2 0 24p
RB2 b2 0 20k
.control
  ac lin 60001 9meg 12meg
  meas ac pico_L_nominal max vm(t0)
  meas ac pico_L_mas_1pc max vm(t1)
  meas ac pico_L_mas_5pc max vm(t5)
  meas ac pico_L_mas_10pc max vm(t10)
  meas ac pico_B1_C13 max vm(b1)
  meas ac pico_B2_C27 max vm(b2)
  echo "Frecuencias de resonancia: el valor at= de cada medida (Hz)."
  echo "Esperado: 10,730 MHz; 10,677 (-53 kHz); 10,472 (-259 kHz); 10,231 (-499 kHz); B1 ~10,61 MHz; B2 ~11,78 MHz"
.endc
.end
