* Capitulo 26, ejercicio 26.3
* LED con V_F = 2 V a 10 mA, alimentado desde 5 V con R = 300 ohm (modelo de caida constante).
* El LED se modela con un diodo (N = 2, IS = 1,6e-19 A) ajustado para dar 2,00 V a 10 mA, asi que
* la simulacion comprueba la cuenta R = (5 - 2)/0,01 = 300 ohm -> I = 10 mA.
* Ejecutar:  ngspice -b ej-26.3_led.cir
.options TNOM=26.85 TEMP=26.85
.model LEDR D(IS=1.6e-19 N=2 RS=0 CJO=0)
V1 vcc 0 5
R1 vcc a 300
D1 a 0 LEDR
.control
op
let iled = (v(vcc)-v(a))/300
print v(a) iled
.endc
.end
