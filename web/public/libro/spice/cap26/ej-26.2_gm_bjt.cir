* Capitulo 26, ejercicio 26.2
* BJT con I_C = 2 mA y beta = 150, con V_T = 26 mV (la temperatura se fija en 28,57 C,
* que es la que da kT/q = 26,00 mV). Libro: g_m = 76,9 mS, r_pi = 1,95 kohm.
* Ejecutar:  ngspice -b ej-26.2_gm_bjt.cir
.options TNOM=28.57 TEMP=28.57
.model QI NPN(IS=1e-15 BF=150 NF=1 VAF=1e9)
VCC vcc 0 5
IB 0 b DC {2m/150}
RC vcc c 1k
Q1 c b 0 QI
.control
op
let vt = 1.380649e-23*(273.15+28.57)/1.602176634e-19
print vt @q1[ic] @q1[gm]
let rpi = 1/@q1[gpi]
print rpi
.endc
.end
