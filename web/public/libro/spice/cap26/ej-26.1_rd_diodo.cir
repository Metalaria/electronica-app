* Capitulo 26, ejercicio 26.1
* Resistencia dinamica de un diodo (n = 1) a 2 mA: r_d = n*V_T/I = 26 mV / 2 mA = 13 ohm.
* Se fija la temperatura en 28,57 C (kT/q = 26,00 mV) y se inyecta 1 A de alterna (pequena
* senal, el analisis AC es lineal): la tension en el diodo es r_d en ohmios.
* Una segunda copia a 26,85 C (V_T = 25,85 mV) da 12,9 ohm.
* Ejecutar:  ngspice -b ej-26.1_rd_diodo.cir
.model DI D(IS=1e-14 N=1 RS=0 CJO=0)
I1 0 a DC 2m AC 1
D1 a 0 DI
.control
set temp=28.57
op
print v(a)
ac lin 1 1k 1k
let rd = real(v(a))
print rd
set temp=26.85
ac lin 1 1k 1k
let rd300 = real(v(a))
print rd300
.endc
.end
