* Capitulo 26, ejercicio 26.4 y ecuacion del MOSFET en saturacion (seccion 26.6)
* k = 2 mA/V2, V_GS - V_th = 2 V: I_D = 1/2*k*(2 V)^2 = 4 mA, g_m = k*V_ov = sqrt(2*k*I_D) = 4 mS.
* Modelo de nivel 1 con KP = k (W = L), VTO = 1 V, V_GS = 3 V, V_DS = 10 V (saturacion), LAMBDA = 0.
* Ejecutar:  ngspice -b ej-26.4_mosfet.cir
.model NM NMOS(LEVEL=1 KP=2m VTO=1 LAMBDA=0)
VGS g 0 3
VDS d 0 10
M1 d g 0 0 NM W=10u L=10u
.control
op
let id = -i(VDS)
print id @m1[gm]
.endc
.end
