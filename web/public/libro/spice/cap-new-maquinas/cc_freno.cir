* P02: regenerative braking: the motor turns at 480 rad/s (E = 24 V) and the supply drops to 12 V at t = 0
VA   a 0 DC 12
VSEN a b DC 0
RA   b c 0.5
LA   c d 5e-05
* back emf E = k*w
BE   d 0 V = 0.05*v(w)
* mechanics: J dw/dt = k*i - T_load (node w: 1 V = 1 rad/s)
BT   0 w I = 0.05*i(VSEN)
CJ   w 0 0.0001
.ic v(w)=480
.tran 5u 0.15 0 5u uic
.control
run
let pfuente = -12*i(VA)
meas tran i_min MIN i(VSEN) from=0 to=2m
meas tran e_fuente INTEG pfuente from=0 to=0.149
meas tran w_fin FIND v(w) AT=0.149
print i_min e_fuente w_fin
.endc
.end
