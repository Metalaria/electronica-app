* P02: the same motor at 24 V with load steps: 0, 0.100 and 0.250 N*m (the table of the chapter)
VA   a 0 DC 24
VSEN a b DC 0
RA   b c 0.5
LA   c d 5e-05
* back emf E = k*w
BE   d 0 V = 0.05*v(w)
* mechanics: J dw/dt = k*i - T_load (node w: 1 V = 1 rad/s)
BT   0 w I = 0.05*i(VSEN)
CJ   w 0 0.0001
IT   w 0 PWL(0 0 0.3 0 0.3001 0.1 0.6 0.1 0.6001 0.25)
.tran 10u 0.9 0 10u uic
.control
run
let rpm = v(w)*60/(2*pi)
meas tran rpm_0 FIND rpm AT=0.299
meas tran rpm_2A FIND rpm AT=0.599
meas tran i_2A FIND i(VSEN) AT=0.599
meas tran rpm_5A FIND rpm AT=0.899
meas tran i_5A FIND i(VSEN) AT=0.899
print rpm_0 rpm_2A i_2A rpm_5A i_5A
.endc
.end
