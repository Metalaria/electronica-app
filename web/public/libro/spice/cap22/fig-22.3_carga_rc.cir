* Capitulo 22, seccion 22.2 (Practica 2), figuras 22.3 y 22.4: carga y descarga RC
* Circuito (a): generador cuadrado 0-5 V, 100 Hz, R = 10 k, C = 100 nF (tau = 1 ms).
*   Comprueba: 63,2 % en 1 tau, 86,5 % en 2 tau, 95,0 % en 3 tau, 99,3 % en 5 tau, y tiempo
*   de subida 10-90 % = 2,2 tau.
* Circuito (b): R = 1 MEG, C = 100 nF (tau nominal 100 ms) y cuadrada bajada a 1 Hz (5 tau por
*   semiciclo), con la sonda x10 (10 MEG || 12 pF) en el condensador.
*   Comprueba: tension final 90,9 % y constante efectiva 0,91 tau = 91 ms.
* Ejecutar: ngspice -b fig-22.3_carga_rc.cir
VG1 g1 0 PULSE(0 5 0 1n 1n 5m 10m)
R1 g1 c1 10k
C1 c1 0 100n IC=0
VG2 g2 0 PULSE(0 5 0 1n 1n 0.5 1)
R2 g2 c2 1MEG
C2 c2 0 100n IC=0
RP c2 0 10MEG
CP c2 0 12p
.tran 2u 1 0 50u UIC
.control
run
meas tran v1t find v(c1) at=1m
meas tran v2t find v(c1) at=2m
meas tran v3t find v(c1) at=3m
meas tran v5t find v(c1) at=5m
let p1 = v1t/5*100
let p2 = v2t/5*100
let p3 = v3t/5*100
let p5 = v5t/5*100
print p1 p2 p3 p5
meas tran t10 when v(c1)=0.5 rise=1
meas tran t90 when v(c1)=4.5 rise=1
let tr_tau = (t90-t10)/1m
print tr_tau
meas tran vfin find v(c2) at=0.5
let pfin = vfin/5*100
print pfin
* constante efectiva: tiempo para llegar al 63,2 % del valor final
let v63 = 0.632*vfin
meas tran teff when v(c2)=v63 rise=1
print teff
.endc
.end
