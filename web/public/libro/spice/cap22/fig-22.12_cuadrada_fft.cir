* Capitulo 22, seccion 22.6 (Practica 6), figuras 22.12 y 22.13: armonicos de una cuadrada
* Generador de 1 kHz conectado al CH1; el analisis de Fourier (.four) sustituye a la FFT.
* Comprueba: solo armonicos impares (pares ~ 0), amplitud 1/n: 3.o -9,5 dB, 5.o -14,0 dB,
* 7.o -16,9 dB; en la triangular, 1/n^2 (3.o -19,1 dB); en la sierra, todos con 1/n.
* Ejecutar: ngspice -b fig-22.12_cuadrada_fft.cir
VSQ sq 0 PULSE(-1 1 0 1n 1n 0.5m 1m)
RSQ sq 0 1k
VTR tr 0 PULSE(-1 1 0 0.5m 0.5m 1n 1m)
RTR tr 0 1k
VSW sw 0 PULSE(-1 1 0 1m 1n 1n 1m)
RSW sw 0 1k
.tran 0.1u 5m 0 0.1u
.options nofreeze
.control
run
fourier 1k v(sq) v(tr) v(sw)
.endc
.end
