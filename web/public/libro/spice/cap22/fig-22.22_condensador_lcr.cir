* Capitulo 22, seccion 22.13 (Practica 13), figura 22.22: impedancia de un electrolitico
* 100 uF con ESL de 30 nH y ESR fija de 0,08 ohm (la figura añade un termino de perdidas
* dielectricas que crece a baja frecuencia; aqui se omite). Comprueba la autorresonancia en
* torno a 92 kHz (frecuencia del minimo de |Z|), donde |Z| baja hasta la ESR, y |Z| = 13,3 ohm a 120 Hz (domina 1/wC).
* Ejecutar: ngspice -b fig-22.22_condensador_lcr.cir
V1 in 0 AC 1
VM in a DC 0
R1 a b 0.08
L1 b c 30n
C1 c 0 100u
.ac dec 500 10 2MEG
.control
run
let z = mag(v(in)/i(VM))
meas ac zmin min z
meas ac z120 find z at=120
meas ac z100k find z at=100k
.endc
.end
