* P09: ideal T line, Z0 = 50 ohm, TD = 5.0035 ns, load 50
VS s 0 PULSE(0 1 1n 0.5n 0.5n 100n 200n)
RS s in 50
T1 in 0 out 0 Z0=50 TD=5.003461n
RL out 0 50
.tran 10p 30n 0 10p
.end
