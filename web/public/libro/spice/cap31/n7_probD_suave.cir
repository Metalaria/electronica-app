* Problem 30.D: PID Kp = 188.7600, Ti = 0.4791 s, Td = 0.1198 s, Tf = Td/10, on 1/((s+1)(s+3)(s+10)), unit step
V1 r 0 PWL(0 0 1u 1)
Be e 0 V=V(r)-V(y)
Bx1 0 x1 I=1*V(e)-V(x1)
Cx1 x1 0 0.011977209706
Bx2 0 x2 I=393.998278049*V(e)
Cx2 x2 0 1
Rx2 x2 0 1e12
Bs3 s3 0 V=(2076.36)*V(e)+(1)*V(x2)+(-1887.6)*V(x1)
Bx4 0 x4 I=0.0333333333333*V(s3)-V(x4)
Cx4 x4 0 1
Bx5 0 x5 I=1*V(x4)-V(x5)
Cx5 x5 0 0.333333333333
Bx6 0 x6 I=1*V(x5)-V(x6)
Cx6 x6 0 0.1
By y 0 V=V(x6)
.options reltol=1e-6 abstol=1e-12 vntol=1e-9
.tran 0.2m 10 0 0.2m
.end
