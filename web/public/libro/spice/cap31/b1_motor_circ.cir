* P06 B1: DC motor (R = 0.5 ohm, L = 1 mH, k = 0.05 V s/rad, J = 5e-4 kg m2, B = 2e-5 N m s/rad) as a circuit
* mobility analogy on the mechanical side: v(w) is the speed in rad/s, the current into CJ the net torque
V1 va 0 PWL(0 0 1u 24)

R1 va a 0.5
L1 a b 0.001
VI b c 0
E1 c 0 w 0 0.05
F1 0 w VI 0.05
CJ w 0 0.0005
RB w 0 50000
IL w 0 PWL(0 0 0.5 0 0.500001 0.1)

.options reltol=1e-6 abstol=1e-12 vntol=1e-9
.tran 0.1m 1 uic
.end
