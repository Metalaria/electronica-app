* Exercise 30.12: K/(s (s+1)(s+2)(s+3)), K = 10 (marginal, 1 rad/s), unit step
V1 r 0 PWL(0 0 1u 1)
Be e 0 V=V(r)-V(y)
Bx1 0 x1 I=1.66666666667*V(e)
Cx1 x1 0 1
Rx1 x1 0 1e12
Bx2 0 x2 I=1*V(x1)-V(x2)
Cx2 x2 0 1
Bx3 0 x3 I=1*V(x2)-V(x3)
Cx3 x3 0 0.5
Bx4 0 x4 I=1*V(x3)-V(x4)
Cx4 x4 0 0.333333333333
By y 0 V=V(x4)
.options reltol=1e-6 abstol=1e-12 vntol=1e-9
.tran 1m 60 0 1m
.end
