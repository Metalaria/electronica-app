* Position servo 100/(s(s+10)) with state feedback K = [4 0.1], N = 4; load step (1 V equivalent) at 1 s
* Book: section 31.12 (label sec-31.12), figure fig-new-31-estados; plant 100/(s(s+10)), states angle and speed
Vr r 0 PWL(0 0 1u 1)
Vd d 0 PWL(0 0 1 0 1.000001 1)
Bth 0 th I=V(w)
Cth th 0 1
Rth th 0 1e12
Bw 0 w I=-10*V(w)+100*V(u)-100*V(d)
Cw w 0 1
Rw w 0 1e12
Bu u 0 V=4*V(r)-4*V(th)-0.1*V(w)
.options reltol=1e-6 abstol=1e-12 vntol=1e-9
.tran 0.1m 2 0 0.1m uic
.meas tran thmax MAX V(th) FROM=0 TO=0.99
.meas tran thfin FIND V(th) AT=1.99
.end
