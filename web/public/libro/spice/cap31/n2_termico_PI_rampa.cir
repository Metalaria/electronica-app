* Thermal plant 0.8/(120 s + 1), PI Kc = 5, Ti = 120 s, setpoint ramp of 2 degC/min
V1 r 0 PWL(0 0 1200 40)
Be e 0 V=V(r)-V(y)
Bx1 0 x1 I=0.0416666666667*V(e)
Cx1 x1 0 1
Rx1 x1 0 1e12
Bs2 s2 0 V=(5)*V(e)+(1)*V(x1)
Bx3 0 x3 I=0.8*V(s2)-V(x3)
Cx3 x3 0 120
By y 0 V=V(x3)
.options reltol=1e-6
.tran 0.1 1200 0 0.1
.end
