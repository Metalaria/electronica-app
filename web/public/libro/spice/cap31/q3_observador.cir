* Integral state feedback using a full-order observer (L = [190 8100], poles -100 double);
* Book: section 31.12 (label sec-31.12), figure fig-new-31-estados; plant 100/(s(s+10)), states angle and speed
* only the angle is measured; load step at 1 s
Vr r 0 PWL(0 0 1u 1)
Vd d 0 PWL(0 0 1 0 1.000001 1)
Bth 0 th I=V(w)
Cth th 0 1
Rth th 0 1e12
Bw 0 w I=-10*V(w)+100*V(u)-100*V(d)
Cw w 0 1
Rw w 0 1e12
Bq 0 q I=V(r)-V(th)
Cq q 0 1
Rq q 0 1e12
* observer: copy of the model corrected with the angle error
Bthh 0 thh I=V(wh)+190*(V(th)-V(thh))
Cthh thh 0 1
Rthh thh 0 1e12
Bwh 0 wh I=-10*V(wh)+100*V(u)+8100*(V(th)-V(thh))
Cwh wh 0 1
Rwh wh 0 1e12
Bu u 0 V=-8*V(thh)-0.3*V(wh)+80*V(q)
.options reltol=1e-6 abstol=1e-12 vntol=1e-9
.tran 0.1m 2 0 0.1m uic
.meas tran thmax MAX V(th) FROM=0 TO=0.99
.meas tran thmin MIN V(th) FROM=1 TO=1.99
.meas tran thfin FIND V(th) AT=1.99
.meas tran werr FIND V(wh) AT=1.99
.end
