* Op-amp lead network: Z1 = R1 || (R3 + 1/(s C1)), feedback R2
V1 x 0 AC 1
R1 x n 100k
R3 x m 24k
C1 m n 390n
R2 n o 100k
Eop o 0 0 n 1e6
.ac dec 2000 0.1 10k
.end
