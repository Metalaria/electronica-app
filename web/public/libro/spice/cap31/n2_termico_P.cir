* Thermal plant 0.8/(120 s + 1), P control Kc = 5, setpoint step of 10 degC
V1 r 0 PWL(0 0 1m 10)
Be e 0 V=V(r)-V(y)
Bs1 s1 0 V=(5)*V(e)
Bx2 0 x2 I=0.8*V(s1)-V(x2)
Cx2 x2 0 120
By y 0 V=V(x2)
.options reltol=1e-6
.tran 0.1 1200 0 0.1
.end
