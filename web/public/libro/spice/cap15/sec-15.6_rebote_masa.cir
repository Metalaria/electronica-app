* Capitulo 15, secciones 15.6 y 15.10, problema 15.B y figura 15.1: tension inducida
* v = L di/dt en la inductancia del protoboard y de los cables de puente.
* Cada caso es una rampa de corriente (fuente PWL) que atraviesa una inductancia a masa; la
* tension en la inductancia durante la rampa es el rebote. Una resistencia de 1 kohm en
* paralelo amortigua el escalon de di/dt sin alterar la meseta.
* Comprueba:
*   - seccion 15.6: una salida que conmuta 20 mA en 2 ns sobre 10 nH -> 100 mV; ocho a la
*     vez (160 mA en 2 ns) -> 800 mV;
*   - figura 15.1: 100 mA en 1 ns sobre 10 nH -> 1 V;
*   - seccion 15.10: 100 mA en 100 ns sobre 100 nH (10 cm de cable) -> 100 mV;
*   - problema 15.B: un convertidor que conmuta 2 A en 20 ns: sobre los 15 nH de contactos e
*     hilos cortos -> 1,5 V; sobre 100 nH de cables de puente -> 10 V (el texto decia «decenas
*     de voltios» con solo los 15 nH, lo que exagera un orden de magnitud).
* Ejecutar: ngspice -b sec-15.6_rebote_masa.cir

* (a) 20 mA en 2 ns, 10 nH
I1 0 n1 PWL(0 0 10n 0 12n 20m)
L1 n1 0 10n
R1 n1 0 1k
* (b) 8 x 20 mA en 2 ns, 10 nH
I2 0 n2 PWL(0 0 10n 0 12n 160m)
L2 n2 0 10n
R2 n2 0 1k
* (c) figura 15.1: 100 mA en 1 ns, 10 nH
I3 0 n3 PWL(0 0 10n 0 11n 100m)
L3 n3 0 10n
R3 n3 0 1k
* (d) 100 mA en 100 ns, 100 nH
I4 0 n4 PWL(0 0 10n 0 110n 100m)
L4 n4 0 100n
R4 n4 0 1k
* (e) 2 A en 20 ns, 15 nH
I5 0 n5 PWL(0 0 10n 0 30n 2)
L5 n5 0 15n
R5 n5 0 1k
* (f) 2 A en 20 ns, 100 nH
I6 0 n6 PWL(0 0 10n 0 30n 2)
L6 n6 0 100n
R6 n6 0 1k

.tran 10p 150n 0 10p
.control
run
meas tran va max v(n1)
meas tran vb max v(n2)
meas tran vc max v(n3)
meas tran vd max v(n4)
meas tran ve max v(n5)
meas tran vf max v(n6)
.endc
.end
