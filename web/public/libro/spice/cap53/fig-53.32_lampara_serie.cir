* Figura 53.32 y tabla de la seccion 53.5 (La lampara serie), ejercicio 53.4.
* La bombilla incandescente se modela con su resistencia en caliente R = V^2/P a 230 V
* (40 W -> 1322 ohm, 60 W -> 882 ohm, 100 W -> 529 ohm). Con el equipo en cortocircuito toda
* la tension cae en la bombilla y la corriente es la maxima de la tabla: 174, 261 y 435 mA.
* (En frio la resistencia del filamento es unas diez veces menor; el destello del encendido es eso.)
* Se usa el valor eficaz como tension continua equivalente, que da los mismos eficaces en una
* carga resistiva.
* Ejecutar:  ngspice -b fig-53.32_lampara_serie.cir
VR l 0 DC 230
R40 l k40 {230*230/40}
RK40 k40 0 1m
R60 l k60 {230*230/60}
RK60 k60 0 1m
R100 l k100 {230*230/100}
RK100 k100 0 1m
.control
op
let i40 = v(k40)/1m
let i60 = v(k60)/1m
let i100 = v(k100)/1m
print i40 i60 i100
.endc
.end
