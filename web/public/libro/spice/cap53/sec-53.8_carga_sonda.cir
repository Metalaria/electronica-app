* Seccion 53.8 (La sonda carga el circuito): tabla de cortes de la sonda P6100 del FNIRSI 2C53T.
* Nodo de 10 kohm y de 100 kohm medido con la sonda en x1 (1 Mohm || ~100 pF) y en x10
* (10 Mohm || ~20 pF). La capacidad forma con el nodo un paso bajo f = 1/(2 pi R C).
* El texto da: x1 -> 161 kHz (10 k) y 17,5 kHz (100 k); x10 -> 797 kHz y 80,4 kHz.
* La resistencia de la sonda queda en paralelo con el nodo: con 100 k y la x1 (1 Mohm) la R
* efectiva es 91 kohm y el corte sube de 15,9 a 17,5 kHz.
* Ejecutar:  ngspice -b sec-53.8_carga_sonda.cir
VS s 0 DC 0 AC 1
R1 s n1 10k
RP1 n1 0 1Meg
CP1 n1 0 100p
R2 s n2 100k
RP2 n2 0 1Meg
CP2 n2 0 100p
R3 s n3 10k
RP3 n3 0 10Meg
CP3 n3 0 20p
R4 s n4 100k
RP4 n4 0 10Meg
CP4 n4 0 20p
.control
ac dec 400 100 100Meg
let r1 = vm(n1)[0]/sqrt(2)
let r2 = vm(n2)[0]/sqrt(2)
let r3 = vm(n3)[0]/sqrt(2)
let r4 = vm(n4)[0]/sqrt(2)
meas ac fc_x1_10k   when vm(n1)=$&r1
meas ac fc_x1_100k  when vm(n2)=$&r2
meas ac fc_x10_10k  when vm(n3)=$&r3
meas ac fc_x10_100k when vm(n4)=$&r4
.endc
.end
