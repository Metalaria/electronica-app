* Figura 53.26 y seccion 53.17 (Medir corriente con el osciloscopio), ejercicio 53.5.
* Shunt en el retorno a masa: fuente -> carga -> shunt -> masa. La carga se modela como una
* fuente de corriente para fijar la corriente de cada fila de la tabla.
* El texto da: 0,1 ohm con 20 mA -> 2 mV; 500 mA -> 50 mV y 25 mW; 2 A -> 200 mV y 0,4 W;
* 1 ohm con 500 mA -> 0,25 W; 2 A -> 2 V y 4 W. Ejercicio 53.5: 35 mV -> 350 mA y 12,3 mW.
* Ejecutar:  ngspice -b fig-53.26_shunt.cir
VS v 0 DC 12
* .dc barre la corriente de carga; los shunts de 0,1 y 1 ohm en dos ramas iguales
IL1 v s1 DC 0
RSH1 s1 0 0.1
IL2 v s2 DC 0
RSH2 s2 0 1
.control
foreach i 20m 350m 500m 2
  alter IL1 dc = $i
  alter IL2 dc = $i
  op
  let v01 = v(s1)
  let p01 = v(s1)*v(s1)/0.1
  let v1 = v(s2)
  let p1 = v(s2)*v(s2)/1
  echo "I = $i"
  print v01 p01 v1 p1
end
.endc
.end
