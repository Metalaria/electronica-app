* Figura 53.12 y tabla de tensiones fantasma de la seccion 53.7 (Nivel avanzado), ejercicio 53.8.
* Un conductor desconectado acoplado por 100 pF, 1 nF o 220 pF a otro de 230 V / 50 Hz.
* El multimetro es una resistencia de 10 Mohm; la prueba anade 10 kohm en paralelo.
* El texto da: 100 pF -> 69 V (10 Mohm) y 72 mV (con 10 kohm); 1 nF -> 219 V y 0,7 V;
* ejercicio 53.8 (220 pF) -> unos 131 V y unos 160 mV.
* Analisis .ac a 50 Hz con 230 V eficaces de amplitud: vm() da directamente el eficaz.
* Ejecutar:  ngspice -b fig-53.12_tension_fantasma.cir
VL l 0 DC 0 AC 230
* 100 pF
CA l a 100p
RA a 0 10Meg
CB l b 100p
RB b 0 {1/(1/10Meg+1/10k)}
* 1 nF
CC l c 1n
RC c 0 10Meg
CD l d 1n
RD d 0 {1/(1/10Meg+1/10k)}
* 220 pF (ejercicio 53.8)
CE l e 220p
RE e 0 10Meg
CF l f 220p
RF f 0 {1/(1/10Meg+1/10k)}
.control
ac lin 1 50 50
print vm(a) vm(b) vm(c) vm(d) vm(e) vm(f)
.endc
.end
