* Seccion 53.27 (Un caso completo): la resistencia de arranque de la fuente de 12 V / 2 A.
* Dos resistencias de 220 kohm en serie llevan corriente desde el bus de primario (unos 320 V)
* al pin de alimentacion del controlador, que en funcionamiento sostiene el bobinado auxiliar a
* 13,4 V (aqui, una fuente ideal a traves de un diodo 1N4148). El condensador de arranque
* (47 uF) no interviene en continua.
* El texto da: unos 700 uA, algo mas de 200 mW repartidos entre los dos cuerpos y unos 150 V
* permanentes en cada resistencia.
* Ejecutar:  ngspice -b sec-53.27_resistencia_arranque.cir
.model D1N4148 D(IS=2.52n RS=0.568 N=1.752 CJO=4p M=0.4 TT=20n BV=100 IBV=100u)
VBUS bus 0 DC 320
R1 bus m 220k
R2 m vcc 220k
CVCC vcc 0 47u
* controlador en marcha: consumo propio de unos 3 mA desde el pin VCC
ICTL vcc 0 DC 3m
* bobinado auxiliar rectificado que sostiene VCC
VAUX aux 0 DC 14.05
DAUX aux vcc D1N4148
.control
op
let i_arranque = (v(bus)-v(vcc))/440e3
let p_total = (v(bus)-v(vcc))*i_arranque
let v_r1 = v(bus)-v(m)
let v_r2 = v(m)-v(vcc)
print v(vcc) i_arranque p_total v_r1 v_r2
.endc
.end
