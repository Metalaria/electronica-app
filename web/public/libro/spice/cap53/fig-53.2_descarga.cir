* Figura 53.2 y seccion 53.2 (Seguridad) + ejercicio 53.3 + seccion 53.22 (La secuencia).
* Descarga del condensador de primario de 470 uF cargado a 320 V con 100 ohm, 1 kohm y 10 kohm,
* y del condensador de 1000 uF a 400 V del ejercicio 53.3 con 1 kohm.
* El texto da: 24 J almacenados; con 1 kohm tau = 0,47 s, 5 tau = 2,35 s, por debajo de 30 V
* en 1,11 s y potencia inicial de 102 W; con 10 kohm, 11 s hasta 30 V. Ejercicio 53.3: 80 J,
* tau = 1 s, 160 W de potencia inicial y menos del 1 % a los 5 s.
* Ejecutar:  ngspice -b fig-53.2_descarga.cir
C1 a 0 470u IC=320
R1 a 0 1k
C2 b 0 470u IC=320
R2 b 0 100
C3 c 0 470u IC=320
R3 c 0 10k
C4 d 0 1000u IC=400
R4 d 0 1k
.control
tran 1m 15 uic
let e470 = 0.5*470e-6*320^2
let e1000 = 0.5*1000e-6*400^2
print e470 e1000
meas tran t30_1k   when v(a)=30 fall=1
meas tran t30_100  when v(b)=30 fall=1
meas tran t30_10k  when v(c)=30 fall=1
meas tran v_5tau_1k find v(a) at=2.35
meas tran v_5s_ej3 find v(d) at=5
let p1k = v(a)*v(a)/1000
let pej3 = v(d)*v(d)/1000
meas tran p0_1k max p1k
meas tran p0_ej3 max pej3
meas tran e_r1k integ p1k from=0 to=15
.endc
.end
