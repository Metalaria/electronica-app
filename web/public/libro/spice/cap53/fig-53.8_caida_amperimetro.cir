* Figura 53.8 (a) y seccion 53.7 (La caida del propio instrumento al medir corriente),
* ejercicio 53.2.
* Un rail de 3,3 V alimenta una carga a traves del multimetro en el rango mA (shunt del orden de
* 10 ohm) o en el rango A (del orden de 0,01 ohm). La carga es una fuente de corriente.
* El texto da: 10 mV con 1 mA y 500 mV con 50 mA en mA (la carga queda a 2,8 V);
* 0,5 mV con 50 mA y 10 mV con 1 A en A; ejercicio 53.2: 30 mA -> unos 300 mV (9 %) en mA y
* 0,3 mV en A.
* Ejecutar:  ngspice -b fig-53.8_caida_amperimetro.cir
V33 v 0 DC 3.3
RMA v cma 10
ILA cma 0 DC 0
RA v ca 0.01
ILB ca 0 DC 0
.control
* rango mA (el fusible de 440 mA limita su uso)
foreach i 1m 30m 50m
  alter ILA dc = $i
  op
  let caida_mA = v(v)-v(cma)
  let carga_mA = v(cma)
  echo "rango mA, I = $i"
  print caida_mA carga_mA
end
* rango A
foreach i 30m 50m 1
  alter ILB dc = $i
  op
  let caida_A = v(v)-v(ca)
  echo "rango A, I = $i"
  print caida_A
end
.endc
.end
