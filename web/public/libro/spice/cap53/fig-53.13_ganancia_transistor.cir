* Figura 53.13 y seccion 53.7 (Lo que el instrumento no mide directamente: ganancia hFE),
* ejercicio 53.7.
* Emisor a masa, base a +9 V por 1 Mohm, colector a +9 V por 1 kohm; el Brymen lee la caida en
* la resistencia de colector. El texto da I_B = 8,35 uA y caidas de 0,84 / 1,67 / 2,50 V para
* hFE = 100 / 200 / 300, y hFE ~ 150 para 1,25 V (ejercicio 53.7).
* Cuatro NPN de tipo 2N3904 que solo difieren en BF (ganancia directa).
* Ejecutar:  ngspice -b fig-53.13_ganancia_transistor.cir
.model N100 NPN(IS=6.7f BF=100 VAF=1000 NF=1)
.model N150 NPN(IS=6.7f BF=150 VAF=1000 NF=1)
.model N200 NPN(IS=6.7f BF=200 VAF=1000 NF=1)
.model N300 NPN(IS=6.7f BF=300 VAF=1000 NF=1)
VCC v 0 DC 9
RB1 v b1 1Meg
RC1 v c1 1k
Q1 c1 b1 0 N100
RB2 v b2 1Meg
RC2 v c2 1k
Q2 c2 b2 0 N150
RB3 v b3 1Meg
RC3 v c3 1k
Q3 c3 b3 0 N200
RB4 v b4 1Meg
RC4 v c4 1k
Q4 c4 b4 0 N300
.control
op
let ib = (v(v)-v(b1))/1e6
let vrc100 = v(v)-v(c1)
let vrc150 = v(v)-v(c2)
let vrc200 = v(v)-v(c3)
let vrc300 = v(v)-v(c4)
let vbe = v(b1)
print ib vbe vrc100 vrc150 vrc200 vrc300
let hfe150 = (vrc150/1e3)/ib
print hfe150
.endc
.end
