* Figura 53.11 y tabla de error de carga de la seccion 53.7 (y el 1 % / 50 % de la seccion 53.8).
* Una fuente de 1 V con impedancia interna de 10 k, 100 k, 1 M y 10 Mohm medida con los 10 Mohm
* del multimetro (o de la sonda x10). El texto da errores de 0,10 %, 0,99 %, 9,09 % y 50 %.
* Ejecutar:  ngspice -b fig-53.11_error_carga.cir
V1 s 0 DC 1
RS1 s a 10k
RM1 a 0 10Meg
RS2 s b 100k
RM2 b 0 10Meg
RS3 s c 1Meg
RM3 c 0 10Meg
RS4 s d 10Meg
RM4 d 0 10Meg
.control
op
let err10k  = 100*(1-v(a))
let err100k = 100*(1-v(b))
let err1M   = 100*(1-v(c))
let err10M  = 100*(1-v(d))
print err10k err100k err1M err10M
.endc
.end
