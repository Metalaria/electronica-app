* Seccion 53.26 (Amplificadores de audio) y ejercicios 53.10 y 53.11.
* (1) Continua de salida sobre un altavoz: 50 mV y 500 mV sobre 8 ohm, 0,8 V sobre 4 ohm.
*     El texto da 6 mA, 62 mA y, en el ejercicio 53.10, 200 mA y 160 mW.
* (2) Corriente de reposo medida como caida en las resistencias de emisor: 0,22 ohm con 30 y
*     50 mA, 0,10 ohm con 30 mA, y 0,33 ohm con 9,9 mV (ejercicio 53.11). El texto da 6,6 mV,
*     11,0 mV, 3,0 mV y 30 mA.
* Ejecutar:  ngspice -b sec-53.26_amplificador.cir
VO1 o1 0 DC 50m
RL1 o1 0 8
VO2 o2 0 DC 500m
RL2 o2 0 8
VO3 o3 0 DC 0.8
RL3 o3 0 4
IQ1 0 e1 DC 30m
RE1 e1 0 0.22
IQ2 0 e2 DC 50m
RE2 e2 0 0.22
IQ3 0 e3 DC 30m
RE3 e3 0 0.10
VE4 e4 0 DC 9.9m
RE4 e4 0 0.33
.control
op
let i_50mV_8 = v(o1)/8
let i_500mV_8 = v(o2)/8
let i_08V_4 = v(o3)/4
let p_08V_4 = v(o3)*v(o3)/4
print i_50mV_8 i_500mV_8 i_08V_4 p_08V_4
let mv_022_30 = 1000*v(e1)
let mv_022_50 = 1000*v(e2)
let mv_010_30 = 1000*v(e3)
let ma_033 = 1000*v(e4)/0.33
print mv_022_30 mv_022_50 mv_010_30 ma_033
.endc
.end
