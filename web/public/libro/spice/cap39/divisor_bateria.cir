* Sección 39.1 («Los tres errores del cálculo») y figura 39.2: un divisor de 100 kOhm en total
* (dos de 50 kOhm) para medir una batería de 3,3 V consume corriente permanentemente.
* Comprueba: 33 µA continuos, más que un microcontrolador dormido (5 µA en la tabla de la sección);
* y la duración de una CR2032 de 225 mAh solo con ese divisor (unos 0,78 años).
* Ejecutar: ngspice -b divisor_bateria.cir
VBAT bat 0 DC 3.3
R1 bat mid 50k
R2 mid 0 50k
.control
  op
  let i_ua = -i(VBAT)*1e6
  echo "Corriente del divisor (µA; 33):"
  print i_ua
  echo "Tensión en el punto medio (V; 1,65):"
  print v(mid)
  echo "Años de una CR2032 de 225 mAh solo con el divisor (unos 0,78):"
  print 225e-3/(i_ua*1e-6)/8766
.endc
.end
