* Sección 39.7 y figura 39.15 (parte inferior): condensador de reserva para un apagado ordenado.
* Una carga de potencia constante (1 W, fuente B con I = P/V) descarga el condensador entre dos
* tensiones; t = C (V1^2 - V2^2) / (2 P). Casos de la figura: 5,6 mF de 3,3 a 2,7 V,
* 168 µF de 12 a 5 V y 9,3 µF de 48 a 12 V.
* Comprueba: los tres casos aguantan unos 10 ms, y que vigilar el lado de tensión alta exige
* mucha menos capacidad.
* Ejecutar: ngspice -b reserva_apagado.cir
C1 a 0 5.6m IC=3.3
B1 a 0 I='1/max(v(a),0.1)'
C2 b 0 168u IC=12
B2 b 0 I='1/max(v(b),0.1)'
C3 c 0 9.3u IC=48
B3 c 0 I='1/max(v(c),0.1)'
.tran 10u 15m 0 10u uic
.control
  run
  meas tran t1 when v(a)=2.7 fall=1
  meas tran t2 when v(b)=5 fall=1
  meas tran t3 when v(c)=12 fall=1
  echo "Tiempo de reserva a 1 W (ms; unos 10 en los tres casos):"
  print t1*1000 t2*1000 t3*1000
.endc
.end
