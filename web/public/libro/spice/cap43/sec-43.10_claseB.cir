* Secciones 43.7 y 43.10 (y figura 43.1): rendimiento y disipacion de la clase B
* Seguidor complementario NPN/PNP sin polarizacion (clase B pura), +-15 V, carga de 8 ohm.
* Parte 1: el seguidor va dentro del lazo de un operacional ideal (fuente controlada de
*   ganancia 1e5), de modo que la salida reproduce exactamente la senoide pedida y se pueden
*   medir las potencias de la seccion 43.10:
*     Vp = 14 V:   Psalida = 12,25 W, Pconsumida = 16,71 W, rendimiento 73,3 %
*     Vp = 9,55 V (2/pi de VCC): disipacion maxima, 2,85 W por transistor
* Parte 2: el mismo seguidor sin lazo, para ver la zona muerta de +-0,7 V (distorsion de cruce):
*     con 10 V de pico la salida pierde unos 0,7 V; con 1 V queda muy poco; con 0,5 V, casi nada.
* Parte 1c: 20 W en 8 ohm con los +-21 V que recomienda la seccion 43.7: la disipacion maxima por
*   transistor es 21^2/(pi^2*8) = 5,59 W, no los 4 W que da 0,2*20 W (esa cifra supone railes de 17,9 V).
* BF = 1000 para que la corriente de base (que aqui no sale de las fuentes) no falsee el balance.
* Ejecutar:  ngspice -b sec-43.10_claseB.cir
.model QN NPN(IS=1e-12 BF=1000 VAF=1e6)
.model QP PNP(IS=1e-12 BF=1000 VAF=1e6)
VP1 vp1 0 15
VN1 vn1 0 -15
VP2 vp2 0 15
VN2 vn2 0 -15
VP3 vp3 0 15
VN3 vn3 0 -15
* --- 1a) Vp = 14 V, con lazo ---
VSa sa 0 sin(0 14 1k)
Ea ga 0 sa oa 1e5
QNa vp1 ga oa QN
QPa vn1 ga oa QP
RLa oa 0 8
* --- 1b) Vp = 9,55 V, con lazo (fuentes propias para separar las potencias) ---
VSb sb 0 sin(0 9.5493 1k)
Eb gb 0 sb ob 1e5
QNb vp2 gb ob QN
QPb vn2 gb ob QP
RLb ob 0 8
* --- 1c) seccion 43.7: 20 W en 8 ohm (17,9 V de pico) con railes reales de +-21 V,
*     y la excursion del maximo de disipacion con esos railes, 2/pi*21 = 13,37 V ---
VP4 vp4 0 21
VN4 vn4 0 -21
VP5 vp5 0 21
VN5 vn5 0 -21
VSf sf 0 sin(0 17.889 1k)
Ef gf 0 sf of 1e5
QNf vp4 gf of QN
QPf vn4 gf of QP
RLf of 0 8
VSg sg 0 sin(0 13.369 1k)
Eg gg 0 sg og 1e5
QNg vp5 gg og QN
QPg vn5 gg og QP
RLg og 0 8
* --- 2) sin lazo: 10 V, 1 V y 0,5 V de pico en la base ---
VSc sc 0 sin(0 10 1k)
QNc vp3 sc oc QN
QPc vn3 sc oc QP
RLc oc 0 8
VSd sd 0 sin(0 1 1k)
QNd vp3 sd od QN
QPd vn3 sd od QP
RLd od 0 8
VSe se 0 sin(0 0.5 1k)
QNe vp3 se oe QN
QPe vn3 se oe QP
RLe oe 0 8
.control
tran 1u 5m
* se mide sobre los tres ultimos periodos (2 a 5 ms)
let pla = v(oa)*v(oa)/8
let psa = -15*i(vp1) + 15*i(vn1)
let pda = psa - pla
meas tran pout avg pla from=2m to=5m
meas tran psup avg psa from=2m to=5m
let plb = v(ob)*v(ob)/8
let psb = -15*i(vp2) + 15*i(vn2)
let pdb = psb - plb
meas tran poutb avg plb from=2m to=5m
meas tran psupb avg psb from=2m to=5m
meas tran pdisb avg pdb from=2m to=5m
let plf = v(of)*v(of)/8
let pdf = -21*i(vp4) + 21*i(vn4) - plf
let plg = v(og)*v(og)/8
let pdg = -21*i(vp5) + 21*i(vn5) - plg
meas tran poutf avg plf from=2m to=5m
meas tran pdisf avg pdf from=2m to=5m
meas tran pdisg avg pdg from=2m to=5m
meas tran vpc max v(oc) from=2m to=5m
meas tran vpd max v(od) from=2m to=5m
meas tran vpe max v(oe) from=2m to=5m
let eta = pout/psup
let pqb = pdisb/2
echo "Vp = 14 V: Psalida (12,25 W), Pconsumida (16,71 W), rendimiento (0,733):"
print pout psup eta
echo "Vp = 9,55 V: Psalida, Pconsumida, disipacion total y por transistor (2,85 W):"
print poutb psupb pdisb pqb
let pqf = pdisf/2
let pqg = pdisg/2
echo "+-21 V: Psalida a 17,9 V de pico (20 W), disipacion por transistor ahi y en el maximo (5,59 W):"
print poutf pqf pqg
echo "Sin lazo: pico de salida con 10 V, 1 V y 0,5 V de pico a la entrada:"
print vpc vpd vpe
.endc
.end
