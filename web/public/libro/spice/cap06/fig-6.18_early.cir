* fig-6.18 / seccion 6.9 (El efecto Early y la resistencia de salida)
* Transistor con VA = 100 V y corriente de base fija, ajustada para IC ~ 1,324 mA a
* VCE = 6,31 V (punto Q del ejemplo). Se comprueba:
*   - el aumento de IC al pasar VCE de 6,31 a 12 V (libro: +5,35 %)
*   - ro = dVCE/dIC en el punto Q (libro: VA/IC = 75,5 k)
*   - la prolongacion de la curva corta el eje en ~ -VA
* Ejecutar:  ngspice -b fig-6.18_early.cir
* Nota: SPICE (Gummel-Poon) aplica el efecto Early sobre VCB, no sobre VCE; con
* VBE = 0,7 V la diferencia es de un 1 % en VA.
.model QE NPN(IS=2.3e-15 BF=150 VAF=100)
IB 0 b 8.3u
VCE c 0 6.31
Q1 c b 0 QE
.control
dc VCE 0.5 15 0.01
let ic = -i(VCE)
meas dc icq find ic at=6.31
meas dc ic12 find ic at=12
meas dc ic5 find ic at=5
meas dc ic10 find ic at=10
let aumento = (ic12/icq-1)*100
let pend = (ic10-ic5)/5
let ro = 1/pend
let vcorte = 5 - ic5/pend
echo "IC en Q, aumento de 6,31 a 12 V (libro 5,35 %), ro (libro 75,5 k), corte del eje (-VA):"
print icq aumento ro vcorte
.endc
.end
