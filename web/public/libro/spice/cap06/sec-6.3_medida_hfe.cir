* seccion 6.3 (Medida en el banco) - montaje de dos resistencias de la seccion 53.7
* Base a +9 V por 1 M, colector a +9 V por 1 k, emisor a masa. El libro da
* IB = (9 - 0,65)/1 M = 8,35 uA, igual para cualquier transistor, y la ganancia como
* (caida en la resistencia de colector / 1 k) / 8,35 uA.
* Se prueban tres transistores de beta 100, 200 y 400 (BC547 A, B y C, aprox.).
* Ejecutar:  ngspice -b sec-6.3_medida_hfe.cir
VCC vcc 0 9
.subckt hfe vcc params: bf=200
.model QX NPN(IS=1e-14 BF={bf} VAF=1e6)
RB vcc b 1Meg
RC vcc c 1k
Q1 c b 0 QX
.ends
X100 vcc hfe bf=100
X200 vcc hfe bf=200
X400 vcc hfe bf=400
.control
op
let ib = (9-v(x200.b))/1Meg
let h100 = ((9-v(x100.c))/1k)/8.35u
let h200 = ((9-v(x200.c))/1k)/8.35u
let h400 = ((9-v(x400.c))/1k)/8.35u
echo "IB (libro 8,35 uA) y ganancia leida con la formula del libro (100, 200, 400):"
print ib h100 h200 h400
.endc
.end
