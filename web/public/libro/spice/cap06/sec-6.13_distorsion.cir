* seccion 6.13 (Ampliacion: distorsion y linealidad)
* No linealidad polinomica y = a1*x + a2*x^2 + a3*x^3 con a1 = 1, a2 = 0,05, a3 = -0,02,
* excitada con x = A*cos(wt) a 1 kHz para A = 0,5, 1 y 2. Se comprueba con .four:
*   A     HD2      HD3      THD
*   0,5   1,25 %   0,125 %  1,26 % (-38,0 dB)
*   1,0   2,50 %   0,50 %   2,55 % (-31,9 dB)
*   2,0   5,00 %   2,00 %   5,39 % (-25,4 dB)
* Las HD del libro van referidas a a1*A: hay que dividir la amplitud absoluta de cada
* armonico (columna "Magnitude") entre A. La columna normalizada de .four las refiere a la
* fundamental real, que la compresion reduce (a1*A + (3/4)*a3*A^3), y da valores algo mayores.
* y la compresion: la ganancia a la fundamental es a1 + (3/4)*a3*A^2; a A1dB = 2,692 cae
* 1 dB (fuente aparte X1 a esa amplitud).
* Ejecutar:  ngspice -b sec-6.13_distorsion.cir
V05 x05 0 SIN(0 0.5 1k)
V10 x10 0 SIN(0 1 1k)
V20 x20 0 SIN(0 2 1k)
V1d x1d 0 SIN(0 2.692 1k)
B05 y05 0 V = v(x05) + 0.05*v(x05)*v(x05) - 0.02*v(x05)*v(x05)*v(x05)
B10 y10 0 V = v(x10) + 0.05*v(x10)*v(x10) - 0.02*v(x10)*v(x10)*v(x10)
B20 y20 0 V = v(x20) + 0.05*v(x20)*v(x20) - 0.02*v(x20)*v(x20)*v(x20)
B1d y1d 0 V = v(x1d) + 0.05*v(x1d)*v(x1d) - 0.02*v(x1d)*v(x1d)*v(x1d)
R05 y05 0 1k
R10 y10 0 1k
R20 y20 0 1k
R1d y1d 0 1k
.control
tran 1u 5m
fourier 1k v(y05) v(y10) v(y20)
fourier 1k v(y1d)
echo "Para A = 2,692 la fundamental debe salir 0,891 x 2,692 = 2,399 (-1 dB)"
.endc
.end
