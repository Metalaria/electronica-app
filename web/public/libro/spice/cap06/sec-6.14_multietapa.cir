* seccion 6.14 (Ampliacion: amplificadores multietapa) - efecto de carga entre etapas
* Dos etapas de ganancia 100 en vacio (fuentes de tension controladas), la primera con
* Rout1 = 10 k; se varia Rin2. Libro:
*   Rin2 = 1 k -> 909;  10 k -> 5000;  100 k -> 9091;  1 M -> 9901  (ideal 10 000)
* Ejecutar:  ngspice -b sec-6.14_multietapa.cir
VS in 0 dc 1
.subckt dos in out params: rin2=10k
E1 a 0 in 0 100
ROUT1 a b 10k
RIN2 b 0 {rin2}
E2 out 0 b 0 100
.ends
X1k   in o1 dos rin2=1k
X10k  in o2 dos rin2=10k
X100k in o3 dos rin2=100k
X1M   in o4 dos rin2=1Meg
.control
op
echo "Ganancia total con Rin2 = 1 k, 10 k, 100 k, 1 M:"
print v(o1) v(o2) v(o3) v(o4)
.endc
.end
