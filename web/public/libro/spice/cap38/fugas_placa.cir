* cap38, seccion 38.6 «Las fugas que arruinan el diseño» (y figura 38.10)
* Fugas permanentes de placa frente al microcontrolador dormido (1 uA):
*  - divisor de 10 k + 20 k desde 3,3 V  -> el libro da 110 uA
*  - pull-up de 10 k con la linea en bajo -> el libro da 330 uA
* El microcontrolador dormido se modela como una fuente de corriente de 1 uA.
* Ejecutar: ngspice -b fugas_placa.cir
V1 vdd 0 DC 3.3
* divisor de tension permanente
R1 vdd div 10k
R2 div 0 20k
* pull-up con la linea forzada a nivel bajo (pin en bajo = 0 V)
R3 vdd linea 10k
Vbajo linea 0 DC 0
* microcontrolador dormido
Imcu vdd 0 DC 1u
.control
op
let idiv = (v(vdd)-v(div))/10k
let ipull = i(vbajo)
let itot = -i(v1)
print idiv ipull itot
print idiv/1u
.endc
.end
