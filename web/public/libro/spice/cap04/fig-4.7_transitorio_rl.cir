* fig-4.7 / seccion 4.3 (El transitorio RL, deducido)
* Bobina de 10 mH conectada a una fuente de 1 V a traves de 1 k, 100 y 10 ohmios.
* El libro: tau = L/R = 10 us, 100 us y 1 ms; 63,2 % en 1 tau, 95 % en 3 tau, 99,3 % en 5 tau;
* con 100 ohmios el transitorio termina a efectos practicos en 500 us.
* Ejecutar:  ngspice -b fig-4.7_transitorio_rl.cir
V1 in 0 PULSE(0 1 0 1n 1n 1 2)
R1 in a 1k
L1 a 0 10m
R2 in b 100
L2 b 0 10m
R3 in c 10
L3 c 0 10m
.control
tran 0.5u 6m
* corriente final de cada rama: V/R
let i1 = (v(in)-v(a))/1k
let i2 = (v(in)-v(b))/100
let i3 = (v(in)-v(c))/10
meas tran tau1k  when i1=0.632e-3 cross=1
meas tran tau100 when i2=6.32e-3 cross=1
meas tran tau10  when i3=63.2e-3 cross=1
echo "Libro: tau = 10 us, 100 us, 1 ms"
meas tran i100_3tau find i2 at=300u
meas tran i100_5tau find i2 at=500u
echo "Libro: con 100 ohm, 95 % (9,5 mA) en 3 tau y 99,3 % (9,93 mA) en 5 tau"
.endc
.end
