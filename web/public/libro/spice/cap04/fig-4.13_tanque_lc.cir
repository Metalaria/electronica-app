* fig-4.13 / seccion 4.7 (Inductores en circuitos resonantes); ejercicio 4.5
* Tanque de 100 uH y 100 pF. Libro: f0 = 1,592 MHz, sqrt(L/C) = 1000 ohm.
* Serie con 10 ohm: Q = 100, tension sobre C = 100 veces la aplicada, BW = f0/Q = 15,9 kHz.
* Paralelo con 100 k: Q = 100, misma BW.
* Ejercicio 4.5: 253 uH con 100 pF resuena en 1 MHz.
* Ejecutar:  ngspice -b fig-4.13_tanque_lc.cir
* --- serie RLC excitado con 1 V
VS s 0 AC 1
RS s a 10
LS a b 100u
CS b 0 100p
* --- paralelo LC con 100 k, excitado con 1 mA (la tension es la impedancia en kohm/1000)
IP 0 p AC 1m
LP p 0 100u
CP p 0 100p
RP p 0 100k
* --- ejercicio 4.5
IE 0 e AC 1m
LE e 0 253u
CE e 0 100p
RE e 0 1meg
.control
ac lin 20001 1.5meg 1.7meg
let vc = mag(v(b))
meas ac vcmax max vc
let vp = mag(v(p))
meas ac vpmax max vp
let lim = vecmax(vp)/sqrt(2)
meas ac f1 when vp=lim cross=1
meas ac f2 when vp=lim cross=2
let bw = f2 - f1
print bw
echo "Libro: f0 = 1,592 MHz, tension en C = 100 V con 1 V de entrada, BW = 15,9 kHz"
ac lin 20001 0.9meg 1.1meg
let ve = mag(v(e))
meas ac vemax max ve
echo "Libro (ej. 4.5): 1 MHz"
.endc
.end
