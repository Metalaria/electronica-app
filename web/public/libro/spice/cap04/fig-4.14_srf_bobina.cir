* fig-4.14 / secciones 4.3 y 4.8 (autorresonancia)
* Bobina de 100 uH con 5 pF de capacidad parasita (y 2,5 ohm de DCR, valor de la figura).
* Libro: SRF = 7,1 MHz; por encima la impedancia cae como la de un condensador de 5 pF;
* a 30 MHz no bloquea (|Z| ~ 1,1 k, casi la de 5 pF solos, 1,06 k, frente a 18,8 k de wL ideal).
* Ejercicio 4.7: Q = wL/R a 100 kHz con 0,5 ohm = 126 (se comprueba con la rama RQ/LQ).
* Ejecutar:  ngspice -b fig-4.14_srf_bobina.cir
I1 0 a AC 1
R1 a b 2.5
L1 b 0 100u
C1 a 0 5p
* ejercicio 4.7: bobina de 100 uH con 0,5 ohm
IQ 0 q AC 1
RQ q r 0.5
LQ r 0 100u
.control
ac dec 5000 10k 100meg
let z = mag(v(a))
meas ac zsrf max z
meas ac z30m find z at=30meg
echo "Libro: SRF = 7,1 MHz; a 30 MHz se comporta como 5 pF (~1,1 k)"
ac lin 1 100k 100k
let zq = v(q)
let qbob = imag(zq)/real(zq)
print qbob
echo "Libro (ej. 4.7): Q = 126"
.endc
.end
