* fig-4.6 y tabla de la seccion 4.3 (Reactancia inductiva); ejercicio 4.2
* Reactancia de una bobina de 10 mH a 50 Hz, 1 kHz y 100 kHz (libro: 3,1 ohm, 62,8 ohm, 6,28 k)
* y cruce con la de un condensador de 100 nF (libro: f0 = 1/(2*pi*sqrt(LC)) = 5,0 kHz,
* X = 316 ohm). La rama serie LC tiene el minimo de impedancia en f0.
* Ejecutar:  ngspice -b fig-4.6_reactancias.cir
* Fuente de corriente de 1 A: la tension sobre cada elemento es su impedancia.
IL 0 nl AC 1
L1 nl 0 10m
IC 0 nc AC 1
C1 nc 0 100n
* LC serie excitado por tension de 1 V: la corriente es maxima en f0
VS s 0 AC 1
LS s m 10m
CS m n 100n
RS n 0 1m
.control
ac lin 1 50 50
print mag(v(nl))
ac lin 1 1k 1k
print mag(v(nl))
ac lin 1 100k 100k
print mag(v(nl))
ac dec 2000 100 1meg
let xl = mag(v(nl))
let xc = mag(v(nc))
let dif = xl - xc
meas ac fcruce when dif=0
meas ac xcruce find xl when dif=0
let iser = mag(i(VS))
meas ac imaxserie max iser
echo "Libro: f0 ~ 5,0 kHz (5,03 kHz), X_L = X_C ~ 316 ohm"
.endc
.end
