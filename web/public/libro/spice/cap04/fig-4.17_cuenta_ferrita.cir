* fig-4.17 / seccion 4.11 (Ferritas de supresion)
* Cuenta de ferrita de 600 ohm (resistivos) a 100 MHz en serie en un sistema de 50 ohm
* (generador de 50 ohm y carga de 50 ohm). Perdida de insercion = tension en la carga sin cuenta
* frente a con cuenta: 20*log((600 + 100)/100) = 16,9 dB.
* Si la fuente tuviera impedancia nula (solo la carga de 50 ohm): 20*log(650/50) = 22,3 dB, que es
* la cifra que muestra la figura 4.17 (debe corregirse a 17 dB).
* Ejecutar:  ngspice -b fig-4.17_cuenta_ferrita.cir
* sistema de 50 ohm sin cuenta
V1 a 0 AC 1
RS1 a b 50
RL1 b 0 50
* sistema de 50 ohm con cuenta
V2 c 0 AC 1
RS2 c d 50
RF2 d e 600
RL2 e 0 50
* fuente ideal, carga de 50 ohm, con y sin cuenta
V3 f 0 AC 1
RL3 f 0 50
V4 g 0 AC 1
RF4 g h 600
RL4 h 0 50
.control
ac lin 1 100meg 100meg
let il50 = 20*log10(mag(v(b))/mag(v(e)))
let ilideal = 20*log10(mag(v(f))/mag(v(h)))
print il50 ilideal
echo "Libro: 17 dB en un sistema de 50 ohm"
.endc
.end
