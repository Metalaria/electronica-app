* Seccion 4.6 (Transformadores) y deduccion de las Ec. 5 y 6; ejercicio 4.4
* Transformador casi ideal con inductancias acopladas (k = 0,999999, L1 = 1000 H para que la
* corriente magnetizante sea despreciable). Cuatro casos a 50 Hz:
*   1) a = 10, V1 = 230 V, carga de 11,5 ohm: libro V2 = 23 V, I2 = 2 A, I1 = 0,2 A, P = 46 W
*   2) a = 10 con 8 ohm en el secundario: libro, se ve como 800 ohm desde el primario
*   3) 230/12 V y 50 VA (carga 12^2/50 = 2,88 ohm): libro I1 = 217 mA, I2 = 4,17 A
*   4) ejercicio 4.4: 920 espiras de primario, 48 de secundario, 2 A: libro V2 = 12 V, I1 = 104 mA
* L2 = L1/a^2 (la inductancia va con N^2).
* Ejecutar:  ngspice -b sec-4.6_trafo_ideal.cir
V1 p1 0 AC 230
L11 p1 0 1000
L12 s1 0 10
K1 L11 L12 0.999999
RL1 s1 0 11.5
V2 p2 0 AC 230
L21 p2 0 1000
L22 s2 0 10
K2 L21 L22 0.999999
RL2 s2 0 8
V3 p3 0 AC 230
L31 p3 0 1000
L32 s3 0 {1000*(12/230)**2}
K3 L31 L32 0.999999
RL3 s3 0 2.88
V4 p4 0 AC 230
L41 p4 0 1000
L42 s4 0 {1000*(48/920)**2}
K4 L41 L42 0.999999
RL4 s4 0 {12/2}
.control
ac lin 1 50 50
echo "Caso 1"
print mag(v(s1)) mag(v(s1))/11.5 mag(i(V1))
echo "Caso 2: impedancia vista desde el primario"
print mag(v(p2)/i(V2))
echo "Caso 3"
print mag(i(V3)) mag(v(s3))/2.88
echo "Caso 4 (ej. 4.4)"
print mag(v(s4)) mag(v(s4))/6 mag(i(V4))
.endc
.end
