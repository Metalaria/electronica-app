* fig-1.10 (sección 1.9): puente de Wheatstone alimentado con 5 V.
* Rama izquierda R1 (arriba) sobre R2; rama derecha R3 (arriba) sobre Rx; V = V(B) - V(A).
* Comprueba: equilibrado (Rx = 1000) V = 0 con 5 V y con 12 V; Rx = 1010 (+1 %) -> 12,44 mV
* (aproximación lineal V/4*dR/R = 12,5 mV).
* Ejecutar: ngspice -b fig-1.10.cir
* puente desequilibrado, 5 V
VS  t 0 DC 5
R1  t a 1k
R2  a 0 1k
R3  t b 1k
RX  b 0 1010
* puente equilibrado, 5 V
VSE te 0 DC 5
R1E te ae 1k
R2E ae 0 1k
R3E te be 1k
RXE be 0 1k
* puente equilibrado, 12 V (el cero no depende de la alimentación)
VSF tf 0 DC 12
R1F tf af 1k
R2F af 0 1k
R3F tf bf 1k
RXF bf 0 1k
.control
op
let vdes = 1000*(v(b)-v(a))
let vlin = 1000*5/4*0.01
let veq5 = v(be)-v(ae)
let veq12 = v(bf)-v(af)
echo "mV desequilibrado y aproximación lineal:"
print vdes vlin
echo "V en equilibrio con 5 V y con 12 V:"
print veq5 veq12
.endc
.end
