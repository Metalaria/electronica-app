* fig-1.12 (sección 1.11): la tensión se mide en paralelo y la corriente en serie.
* La figura no da valores; aquí se suponen: fuente de 9 V con 0,1 ohm internos, carga de 1 k,
* voltímetro de 10 Mohm y amperímetro de 0,1 ohm (rango de amperios).
* Comprueba: el voltímetro en paralelo lee 8,999 V y apenas cambia la corriente (0,9 uA);
* el amperímetro en serie lee 8,998 mA (error 0,01 %); el mismo amperímetro puesto en paralelo
* con la carga cortocircuita la fuente: 45 A, que funden el fusible del instrumento.
* Ejecutar: ngspice -b fig-1.12.cir
* voltímetro en paralelo
V1  s1 0 DC 9
RI1 s1 a1 0.1
RC1 a1 0 1k
RV1 a1 0 10Meg
* amperímetro en serie (fuente de 0 V para leer su corriente)
V2  s2 0 DC 9
RI2 s2 a2 0.1
RA2 a2 m2 0.1
VM2 m2 b2 DC 0
RC2 b2 0 1k
* amperímetro mal conectado: en paralelo con la carga
V3  s3 0 DC 9
RI3 s3 a3 0.1
RC3 a3 0 1k
RA3 a3 m3 0.1
VM3 m3 0 DC 0
.control
op
let ivolt = v(a1)/10e6
print v(a1) ivolt
let iok = i(VM2)
let err = 100*(1-iok/(9/1000.1))
print iok err
let icorto = i(VM3)
print icorto
.endc
.end
