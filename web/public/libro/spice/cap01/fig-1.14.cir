* fig-1.14 (sección 1.11): error de carga de los instrumentos.
* Voltímetro de 10 Mohm en el punto medio de un divisor de dos resistencias iguales desde 10 V:
*   1 Mohm -> 4,762 V (error 4,8 %); 100 k -> error 0,50 %; 1 k -> 5,000 V (0,005 %).
* Amperímetro de 10 ohm en serie con un circuito de 100 ohm: error 9,1 %.
* Sonda x10 (10 Mohm || 12 pF): a 1 MHz su impedancia es unos 13 kohm. Sonda x1 (1 Mohm || 100 pF): 1,6 kohm.
* Ejecutar: ngspice -b fig-1.14.cir
V1 a 0 DC 10
R1 a m 1Meg
R2 m 0 1Meg
RV1 m 0 10Meg
V2 b 0 DC 10
R3 b n 100k
R4 n 0 100k
RV2 n 0 10Meg
V3 c 0 DC 10
R5 c k 1k
R6 k 0 1k
RV3 k 0 10Meg
* amperímetro de 10 ohm en serie con 100 ohm, desde 1 V
V4 d 0 DC 1
RA d e 10
R7 e 0 100
* sondas excitadas con 1 A de alterna: v = Z
IP10 0 p AC 1
RP10 p 0 10Meg
CP10 p 0 12p
IP1  0 q AC 1
RP1  q 0 1Meg
CP1  q 0 100p
.control
op
let e1m = 100*(1-v(m)/5)
let e100k = 100*(1-v(n)/5)
let e1k = 100*(1-v(k)/5)
print v(m) e1m e100k v(k) e1k
let ea = 100*(1-(v(e)/100)/(1/100))
print ea
ac lin 1 1Meg 1Meg
let z10 = mag(v(p))
let z1 = mag(v(q))
print z10 z1
.endc
.end
