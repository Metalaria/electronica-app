* Comprobación del ejemplo de mallas de la sección 23.4 (Ec. 4), citado desde la sección 1.3.
* Circuito reconstruido a partir de la matriz: fuente de 12 V, 4 ohm propios en la malla 1,
* 8 ohm compartidos y 4 ohm propios en la malla 2.
*   Malla 1: 12 i1 - 8 i2 = 12      Malla 2: -8 i1 + 12 i2 = 0
* Comprueba: i1 = 1,8 A, i2 = 1,2 A; la rama compartida lleva 0,6 A; la fuente entrega 21,6 W
* y las resistencias disipan 12,96 + 2,88 + 5,76 = 21,6 W.
* Ejecutar: ngspice -b mallas_23.4.cir
V1  a 0 DC 12
RA  a n 4
VI2 n p DC 0
RC  p 0 4
VIS n q DC 0
RB  q 0 8
.control
op
let i1 = -i(V1)
let i2 = i(VI2)
let icomp = i(VIS)
print i1 i2 icomp
let pfuente = 12*i1
let pa = 4*i1^2
let pb = 8*icomp^2
let pc = 4*i2^2
let ptot = pa+pb+pc
print pfuente pa pb pc ptot
.endc
.end
