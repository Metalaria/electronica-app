* Sección 1.9: transformación triángulo-estrella.
* Triángulo Ra = 10 (frente al vértice 1, entre 2 y 3), Rb = 20 (entre 1 y 3), Rc = 30 (entre 1 y 2).
* Estrella equivalente: R1 = 10, R2 = 5, R3 = 3,33 ohm.
* Comprueba que la resistencia vista entre cada par de vértices es la misma en las dos redes,
* inyectando 1 A entre ellos (la tensión en voltios es la resistencia en ohmios).
* Ejecutar: ngspice -b estrella_triangulo_1.9.cir
.subckt tri 1 2 3
Ra 2 3 10
Rb 1 3 20
Rc 1 2 30
.ends
.subckt est 1 2 3
R1 1 c 10
R2 2 c 5
R3 3 c {10*20/60}
.ends
* par 1-2
XT12 a12 0 f12 tri
RF12 f12 0 1e12
I12  0 a12 DC 1
XE12 b12 0 g12 est
RG12 g12 0 1e12
I12E 0 b12 DC 1
* par 1-3
XT13 a13 f13 0 tri
RF13 f13 0 1e12
I13  0 a13 DC 1
XE13 b13 g13 0 est
RG13 g13 0 1e12
I13E 0 b13 DC 1
* par 2-3
XT23 f23 a23 0 tri
RF23 f23 0 1e12
I23  0 a23 DC 1
XE23 g23 b23 0 est
RG23 g23 0 1e12
I23E 0 b23 DC 1
.control
op
echo "R entre vértices (triángulo, estrella):"
print v(a12) v(b12) v(a13) v(b13) v(a23) v(b23)
.endc
.end
