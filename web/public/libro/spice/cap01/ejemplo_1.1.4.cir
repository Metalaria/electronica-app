* Sección 1.1.4, ejemplo: resistencia de 220 ohm conectada a 12 V.
* Comprueba: I = 54,5 mA, P = 0,655 W y energía en 30 min = 1178 J (0,327 Wh).
* Ejecutar: ngspice -b ejemplo_1.1.4.cir
V1 a 0 DC 12
R1 a 0 220
.tran 1 1800 0 10
.meas tran imed AVG par('-i(V1)') FROM=0 TO=1800
.meas tran pmed AVG par('-v(a)*i(V1)') FROM=0 TO=1800
.meas tran energia INTEG par('-v(a)*i(V1)') FROM=0 TO=1800
.meas tran wh PARAM='energia/3600'
.end
