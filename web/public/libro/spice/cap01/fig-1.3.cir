* fig-1.3 (sección 1.3/1.4): las dos configuraciones fundamentales.
* Serie: 100 + 220 + 470 ohm con 12 V -> 790 ohm, 15,2 mA, caídas 1,52 + 3,34 + 7,14 V = 12 V.
* Paralelo: los mismos valores con 12 V -> 120 + 54,5 + 25,5 mA = 200 mA, 60,0 ohm.
* Ejecutar: ngspice -b fig-1.3.cir
VS  s1 0 DC 12
R1  s1 s2 100
R2  s2 s3 220
R3  s3 0  470
VP  p1 0 DC 12
VA  p1 pa DC 0
RP1 pa 0 100
RP2 pa 0 220
RP3 pa 0 470
.control
op
echo "--- Serie ---"
let is = -i(VS)
print is
let v1 = v(s1)-v(s2)
let v2 = v(s2)-v(s3)
let v3 = v(s3)
print v1 v2 v3
let suma = v1+v2+v3
let rserie = 12/is
print suma rserie
echo "--- Paralelo ---"
let ip = i(VA)
let i1 = v(pa)/100
let i2 = v(pa)/220
let i3 = v(pa)/470
let rpar = 12/ip
print ip i1 i2 i3 rpar
.endc
.end
