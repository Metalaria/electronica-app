* Sección 1.3, ejemplos de Kirchhoff.
* Nodo: entran 2 A por una rama y salen 1,2 A por otra; por la tercera salen 0,8 A.
* Lazo: fuente de 12 V y 4, 6 y 2 ohm en serie -> 1 A y caídas de 4, 6 y 2 V, que suman 12 V.
* Ejecutar: ngspice -b kirchhoff_1.3.cir
* nodo n: fuente de 2 A que entra, carga de 1,2 A que sale, y una resistencia como tercera rama
IIN  0 n DC 2
IOUT n 0 DC 1.2
VAM  n m DC 0
R3   m 0 10
* lazo
V1 a 0 DC 12
R1 a b 4
R2 b c 6
R4 c 0 2
.control
op
let i3 = i(VAM)
print i3
let ilazo = -i(V1)
let v4 = v(a)-v(b)
let v6 = v(b)-v(c)
let v2 = v(c)
let suma = v4+v6+v2
print ilazo v4 v6 v2 suma
.endc
.end
