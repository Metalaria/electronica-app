* Sección 1.5, superposición: fuentes de 12 V y 6 V, cada una con 1 k en serie, sobre una carga
* común de 2 k. Comprueba: la de 12 V sola aporta 4,80 V, la de 6 V sola 2,40 V, y las dos juntas
* 7,20 V = 4,80 + 2,40. También comprueba que la potencia NO se superpone.
* Ejecutar: ngspice -b superposicion_1.5.cir
* las dos fuentes
VA1 a1 0 DC 12
RA1 a1 n1 1k
VB1 b1 0 DC 6
RB1 b1 n1 1k
RL1 n1 0 2k
* solo la de 12 V (la de 6 V sustituida por un cortocircuito)
VA2 a2 0 DC 12
RA2 a2 n2 1k
RB2 n2 0 1k
RL2 n2 0 2k
* solo la de 6 V
RA3 n3 0 1k
VB3 b3 0 DC 6
RB3 b3 n3 1k
RL3 n3 0 2k
.control
op
let suma = v(n2)+v(n3)
print v(n1) v(n2) v(n3) suma
let ptot = v(n1)^2/2000
let psum = v(n2)^2/2000 + v(n3)^2/2000
echo "Potencia real en la carga y suma (errónea) de potencias parciales, en W:"
print ptot psum
.endc
.end
