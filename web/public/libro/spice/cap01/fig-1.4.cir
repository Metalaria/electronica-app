* fig-1.4 y fig-1.5 (sección 1.4): divisor de tensión 12 V, R1 = 10 k, R2 = 5 k, y efecto de la carga.
* Comprueba: 4,00 V en vacío; 3,00 V con RL = 10 k (-25 %); con RL = 10*(R1||R2) = 33,3 k,
* 3,64 V (error 9,1 % < 10 %); con RL = 100*(R1||R2), error 0,99 %.
* Ejecutar: ngspice -b fig-1.4.cir
.param r1=10k r2=5k rth={r1*r2/(r1+r2)}
* sin carga
V0 a0 0 DC 12
R10 a0 o0 {r1}
R20 o0 0 {r2}
* carga de 10 k
V1 a1 0 DC 12
R11 a1 o1 {r1}
R21 o1 0 {r2}
RL1 o1 0 10k
* carga de 10*Rth
V2 a2 0 DC 12
R12 a2 o2 {r1}
R22 o2 0 {r2}
RL2 o2 0 {10*rth}
* carga de 100*Rth
V3 a3 0 DC 12
R13 a3 o3 {r1}
R23 o3 0 {r2}
RL3 o3 0 {100*rth}
.control
op
let e10k = 100*(1-v(o1)/v(o0))
let e10 = 100*(1-v(o2)/v(o0))
let e100 = 100*(1-v(o3)/v(o0))
print v(o0) v(o1) v(o2) v(o3)
print e10k e10 e100
.endc
.end
