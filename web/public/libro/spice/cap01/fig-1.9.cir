* fig-1.9 (sección 1.8): consumo medio de un nodo que despierta y duerme.
* 8 mA durante 5 ms cada segundo y 3 uA el resto: media de 43 uA; con 2000 mAh, unos 5,3 años
* teóricos. También: un pico de 200 mA durante 1 ms cada segundo son 200 uA de media.
* La carga se modela como fuente de corriente sobre una fuente de 3 V ideal.
* Ejecutar: ngspice -b fig-1.9.cir
VBAT b 0 DC 3
* reposo de 3 uA más pulsos de 8 mA - 3 uA durante 5 ms cada segundo
IREP  b 0 DC 3u
IACT  b 0 PULSE(0 {8m-3u} 0.1 1u 1u 5m 1)
* pico de 200 mA durante 1 ms cada segundo (circuito aparte)
VB2 c 0 DC 3
IPIC c 0 PULSE(0 200m 0.1 1u 1u 1m 1)
.tran 10u 10 0 100u
.meas tran imed AVG par('-i(VBAT)') FROM=0 TO=10
.meas tran anios PARAM='2000e-3/imed/24/365'
.meas tran ipico AVG par('-i(VB2)') FROM=0 TO=10
.end
