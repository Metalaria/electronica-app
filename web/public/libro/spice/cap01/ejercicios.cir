* Ejercicios 1.1 a 1.9 del capítulo 1 (los que son circuitos).
* 1.1: 470 ohm con 25 mA -> 11,75 V y 0,294 W.
* 1.2: 1 k + 2,2 k + 4,7 k con 9 V -> 7900 ohm, 1,139 mA, 1,14 + 2,51 + 5,35 = 9,00 V.
* 1.3: 330 || 220 = 132 ohm; con 5 V, 37,9 mA (15,2 + 22,7 mA).
* 1.4: divisor de 5 V con R1 = 1 k: R2 = 1941 ohm da 3,30 V; con 2 k comercial, 3,33 V.
* 1.6: 50 m de cobre de 2,5 mm2 (0,344 ohm) con 10 A -> 3,44 V y 34,4 W.
* 1.8: regulador lineal de 9 V a 3,3 V con 0,5 A (modelado como resistencia en serie) -> 2,85 W, 36,7 %.
* 1.9: pila de 1,5 V que da 1,35 V con 0,5 A -> Rint = 0,3 ohm.
* (El 1.5, senoide de 17 V de pico sobre 100 ohm, está en rms_1.6.cir; el 1.7 es solo aritmética.)
* Ejecutar: ngspice -b ejercicios.cir
* 1.1
I1  0 n1 DC 25m
R1  n1 0 470
* 1.2
V2  a2 0 DC 9
R2a a2 b2 1k
R2b b2 c2 2.2k
R2c c2 0 4.7k
* 1.3
V3  a3 0 DC 5
R3a a3 0 330
R3b a3 0 220
* 1.4
V4  a4 0 DC 5
R4a a4 b4 1k
R4b b4 0 1941
V4c a4c 0 DC 5
R4c a4c b4c 1k
R4d b4c 0 2k
* 1.6
V6  a6 0 DC 1
R6  a6 b6 {1.72e-8*50/2.5e-6}
I6  b6 0 DC 10
* 1.8: el regulador como resistencia que deja caer 5,7 V con 0,5 A
V8  a8 0 DC 9
R8r a8 b8 11.4
R8l b8 0 6.6
* 1.9: pila de 1,5 V con 0,3 ohm y carga que toma 0,5 A
V9  a9 0 DC 1.5
R9  a9 b9 0.3
I9  b9 0 DC 0.5
.control
op
let p1 = v(n1)*25m
print v(n1) p1
let i2 = -i(V2)
let v2a = v(a2)-v(b2)
let v2b = v(b2)-v(c2)
let v2c = v(c2)
let s2 = v2a+v2b+v2c
print i2 v2a v2b v2c s2
let i3 = -i(V3)
let r3 = 5/i3
let i3a = 5/330
let i3b = 5/220
print r3 i3 i3a i3b
print v(b4) v(b4c)
let c6 = 1-v(b6)
let r6 = c6/10
let p6 = 10*c6
print r6 c6 p6
let i8 = -i(V8)
let pd8 = (9-v(b8))*i8
let eta8 = 100*v(b8)/9
print v(b8) i8 pd8 eta8
let r9 = (1.5-v(b9))/0.5
print v(b9) r9
.endc
.end
