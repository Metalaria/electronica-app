* fig-1.6 (sección 1.5): Thévenin, Norton y máxima transferencia de potencia.
* Red: fuente de 12 V, 4 ohm en serie y 6 ohm a la salida.
* Comprueba: Vth = 7,2 V (vacío), IN = 3 A (cortocircuito), Rth = Vth/IN = 2,4 ohm;
* barriendo la carga, la potencia máxima es 5,40 W en RL = 2,4 ohm, con rendimiento del 50 %
* respecto a la potencia del equivalente Thévenin (1,5 A, 3,6 V).
* Ejecutar: ngspice -b fig-1.6.cir
* copia en vacío
V1 a1 0 DC 12
R11 a1 o1 4
R21 o1 0 6
* copia en cortocircuito (fuente de 0 V como amperímetro)
V2 a2 0 DC 12
R12 a2 o2 4
R22 o2 0 6
VSC o2 0 DC 0
* equivalente Thévenin con carga variable (se barre RL)
VTH t 0 DC 7.2
RTH t o3 2.4
RL  o3 0 1
.control
op
let vth = v(o1)
let isc = i(VSC)
let rth = vth/isc
print vth isc rth
dc RL 0.1 20 0.001
let pl = -v(o3)*i(VTH)
let eta = 100*v(o3)/7.2
meas dc pmax MAX pl
meas dc rlopt MAX_AT pl
meas dc etaopt FIND eta AT=2.4
meas dc iopt FIND i(VTH) AT=2.4
meas dc vopt FIND v(o3) AT=2.4
.endc
.end
