* fig-1.13 (sección 1.11): medida a dos y a cuatro hilos de una resistencia de 5 mohm.
* Cada cable con su contacto vale unos 0,2 ohm.
* Dos hilos: el óhmetro (modelado como fuente de 1 mA que mide la tensión en sus bornes) ve
* 5 m + 2 x 200 m = 405 mohm; el 99 % de la lectura son los cables.
* Cuatro hilos: la fuente de laboratorio en corriente constante inyecta 1,000 A por el par exterior,
* y el Brymen (10 Mohm) mide en mV por el par interior: 5,00 mV -> 5,00 mohm.
* Ejecutar: ngspice -b fig-1.13.cir
* --- dos hilos
IOHM 0 h1 DC 1m
RC1  h1 x1 0.2
RX1  x1 y1 5m
RC2  y1 0  0.2
* --- cuatro hilos: lazo de corriente
IFU  0 f1 DC 1
RC3  f1 x2 0.2
RX2  x2 y2 5m
RC4  y2 0  0.2
* lazo de tensión: cables de 0,2 ohm hasta el voltímetro de 10 Mohm
RS1  x2 v1 0.2
RS2  y2 v2 0.2
RVM  v1 v2 10Meg
.control
op
let r2h = v(h1)/1e-3
let frac = 100*(r2h-5e-3)/r2h
echo "Dos hilos: lectura en ohm y porcentaje debido a los cables"
print r2h frac
let vmv = 1000*(v(v1)-v(v2))
let r4h = (v(v1)-v(v2))/1
echo "Cuatro hilos: lectura en mV y resistencia en ohm"
print vmv r4h
.endc
.end
