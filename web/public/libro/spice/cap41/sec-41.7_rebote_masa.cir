* Seccion 41.7 (Rebote de masa y ruido de conmutacion)
* Ocho salidas que descargan su carga a la vez: cada una toma 20 mA con una rampa de 2 ns,
* y la corriente total (160 mA) vuelve por 5 nH de inductancia de encapsulado (pin y
* conexion de masa). La tension sobre esa inductancia es N*L*di/dt = 8*5n*(20m/2n) = 0,4 V
* durante la rampa: la masa interna del chip se separa 400 mV de la de la placa.
* Se compara con una sola salida (50 mV) para ver el factor N.
* Ejecutar:  ngspice -b sec-41.7_rebote_masa.cir
* corriente de las ocho salidas: rampa de 0 a 160 mA en 2 ns, mantenida
I8 0 gint8 PWL(0 0 1n 0 3n 160m 10n 160m)
L8 gint8 0 5n
I1 0 gint1 PWL(0 0 1n 0 3n 20m 10n 20m)
L1 gint1 0 5n
.tran 1p 10n
.control
run
meas tran rebote_8 MAX v(gint8) from=0 to=10n
meas tran rebote_1 MAX v(gint1) from=0 to=10n
.endc
.end
