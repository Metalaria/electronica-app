* P02: 4 kW induction motor, per-phase Y-equivalent at 50 Hz, slip s = 0.5 (R2'/s = 2.2 ohm)
V1  a 0 AC 230.940108
R1  a b 1.4
L1  b c 0.00636619772
LM  c 0 0.175070437
RFE c 0 2500.0
L2  c d 0.00636619772
VS2 d e AC 0
R2S e 0 2.2
.ac lin 1 50 50
.control
run
let i1 = -i(V1)
let pin = 3*real(v(a)*conj(i1))
let pag = 3*mag(i(VS2))^2*2.2
let tem = pag/157.079632679
print mag(i1) pin pag tem
.endc
.end
