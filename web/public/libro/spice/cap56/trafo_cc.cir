* P02: short-circuit test, referred to the LV side: 4 % of the voltage with the secondary shorted
V1  a 0 AC 9.237604
VI  a b AC 0
RCC b c 0.028
LCC c 0 0.000183187269
.ac lin 1 50 50
.control
run
let pcc = 3*real(v(a)*conj(i(VI)))
print mag(i(VI)) pcc
.endc
.end
