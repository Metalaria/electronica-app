* P02: 100 kVA Dyn11, no-load test on the LV side (per phase, 230.94 V): Rfe || Xm
V1  a 0 AC 230.940108
VI  a b AC 0
RFE b 0 761.904762
LM  b 0 0.342907671
.ac lin 1 50 50
.control
run
let p0 = 3*real(v(a)*conj(i(VI)))
print mag(i(VI)) p0
.endc
.end
