* P02: rated-impedance load at cos 0.8 (1.6 ohm, 36.87 deg), primary at rated voltage (referred to LV)
V1  a 0 AC 230.940108
RFE a 0 761.904762
LM  a 0 0.342907671
VI  a b AC 0
RCC b c 0.028
LCC c d 0.000183187269
RL  d e 1.28
LL  e 0 0.00305577492
.ac lin 1 50 50
.control
run
let v2l = sqrt(3)*mag(v(d))
print v2l mag(i(VI))
.endc
.end
