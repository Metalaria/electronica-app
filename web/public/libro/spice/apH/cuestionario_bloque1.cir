* Apendice H, Bloque I (preguntas 1, 2, 3 y 4) y sus soluciones.
* Comprueba con circuitos minimos los numeros del solucionario:
*   P1: 3 mA por 2,2 kOhm -> 6,6 V
*   P2: 0,5 W con 5 V -> 100 mA (resistencia de 50 Ohm)
*   P3: divisor R1 = 1 kOhm, R2 = 3 kOhm a 8 V -> 6 V en R2
*   P4: carga RC tras t = tau -> 63,2 % de la tension final
* Ejecucion: ngspice -b cuestionario_bloque1.cir
I1 0 n1 3m
R1a n1 0 2.2k
V2 n2 0 5
R2a n2 0 50
V3 n3 0 8
R1 n3 n4 1k
R2 n4 0 3k
V4 n5 0 PULSE(0 1 0 1n 1n 1 2)
R4 n5 n6 1k
C4 n6 0 1u IC=0
.tran 1u 5m UIC
.meas tran VR_P1 FIND v(n1) AT=1m
.meas tran I_P2 FIND i(V2) AT=1m
.meas tran P_P2 FIND par('-v(n2)*i(V2)') AT=1m
.meas tran VR2_P3 FIND v(n4) AT=1m
.meas tran VC_TAU FIND v(n6) AT=1m
.end
