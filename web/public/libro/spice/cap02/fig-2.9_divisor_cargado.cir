* fig-2.9 / seccion 2.7.1 (El divisor de tension y el efecto de carga)
* Divisor de 5 V con R1 = R2 = 10 kohm y una carga RL en paralelo con R2.
* El libro (y la figura) dicen:
*   en vacio Vsal = 2,5 V; con RL = R2 cae a 1,67 V; con RL = 10*R2 queda en 2,38 V (error 4,8 %).
*   Con RL = 10*R2 el error es 0,9 % si R1 = 0,1*R2, 4,8 % si R1 = R2 y 8,3 % si R1 = 10*R2,
*   y nunca supera 1/11 = 9,1 % sea cual sea la relacion R1/R2.
* Se montan varias copias independientes del divisor para leerlas todas con un solo .op.
* Ejecutar:  ngspice -b fig-2.9_divisor_cargado.cir
V1 vcc 0 DC 5
* (a) en vacio, R1 = R2 = 10k
R1a vcc a 10k
R2a a 0 10k
* (b) RL = R2
R1b vcc b 10k
R2b b 0 10k
RLb b 0 10k
* (c) RL = 10*R2, R1 = R2
R1c vcc c 10k
R2c c 0 10k
RLc c 0 100k
* (d) R1 = 0,1*R2, en vacio y con RL = 10*R2
R1d vcc d 1k
R2d d 0 10k
R1e vcc e 1k
R2e e 0 10k
RLe e 0 100k
* (f) R1 = 10*R2, en vacio y con RL = 10*R2
R1f vcc f 100k
R2f f 0 10k
R1g vcc g 100k
R2g g 0 10k
RLg g 0 100k
* (h) caso limite R1 = 1000*R2 con RL = 10*R2: el error tiende a 1/11
R1h vcc h 10Meg
R2h h 0 10k
R1i vcc i 10Meg
R2i i 0 10k
RLi i 0 100k
.control
op
print v(a) v(b) v(c)
let err_r1_igual = 100*(1 - v(c)/v(a))
let err_r1_01 = 100*(1 - v(e)/v(d))
let err_r1_10 = 100*(1 - v(g)/v(f))
let err_limite = 100*(1 - v(i)/v(h))
print err_r1_01 err_r1_igual err_r1_10 err_limite
.endc
.end
