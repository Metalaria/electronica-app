* Problema 2.A (seccion 2.13): divisor de precision, peor caso frente a estadistico
* Divisores alimentados con 1 V, de modo que la tension de salida es directamente k.
* Las resistencias se desplazan un 1 % en sentidos opuestos (peor caso).
* El libro dice: k = 0,5 -> peor caso 1,000 %; k = 0,25 -> 1,500 % en primer orden,
*   y la evaluacion exacta da +1,508 % o -1,493 % segun el sentido.
*   Con resistencias del 0,5 %, k = 0,5 -> 0,5 % en peor caso.
*   Si las dos se desvian en la misma proporcion, k no cambia.
* Ejecutar:  ngspice -b prob-2.A_divisor_tolerancias.cir
V1 in 0 DC 1
* k = 0,5 nominal y peor caso (R1 -1 %, R2 +1 %)
R1a in a 10k
R2a a 0 10k
R1b in b 9.9k
R2b b 0 10.1k
* k = 0,5 con resistencias del 0,5 %
R1c in c 9.95k
R2c c 0 10.05k
* k = 0,5 con las dos desviadas +1 % (apareadas): no cambia
R1d in d 10.1k
R2d d 0 10.1k
* k = 0,25 (R1 = 30k, R2 = 10k): nominal y los dos sentidos del peor caso
R1e in e 30k
R2e e 0 10k
R1f in f 29.7k
R2f f 0 10.1k
R1g in g 30.3k
R2g g 0 9.9k
.control
op
let e05 = 100*(v(b)/v(a) - 1)
let e05_05 = 100*(v(c)/v(a) - 1)
let e05_apareado = 100*(v(d)/v(a) - 1)
let e025_mas = 100*(v(f)/v(e) - 1)
let e025_menos = 100*(v(g)/v(e) - 1)
print v(a) v(e)
print e05 e05_05 e05_apareado
print e025_mas e025_menos
.endc
.end
