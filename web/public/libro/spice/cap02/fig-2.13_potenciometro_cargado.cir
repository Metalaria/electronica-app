* fig-2.13 / seccion 2.11 (El efecto de la carga, y como deforma la ley)
* Potenciometro lineal de 10 kohm alimentado con 1 V, con una carga de 10 kohm (igual a R) en el cursor.
* El potenciometro se modela con dos resistencias comportamentales: (1-x)*R arriba y x*R abajo,
* donde x (posicion del cursor, 0 a 1) es la tension de la fuente auxiliar Vx, que se barre con .dc.
* El libro dice: al 50 % del recorrido la salida es el 40 % (no el 50 %); la desviacion maxima
*   es de 12 puntos hacia el 69 % del recorrido (12,2 puntos al 69 %).
* Ejecutar:  ngspice -b fig-2.13_potenciometro_cargado.cir
Vx x 0 DC 0.5
V1 in 0 DC 1
Rarr in w r = {10k*(1 - V(x)) + 1m}
Raba w 0 r = {10k*V(x) + 1m}
RL w 0 10k
.dc Vx 0.01 0.99 0.001
* salida en % del recorrido al 50 %
.meas dc sal_50 find v(w) at=0.5
* desviacion respecto a la ley sin carga (x - salida), en puntos; el valor 'at' es la posicion x del maximo
.meas dc desv_max max par('100*(v(x) - v(w))')
.end
