* Seccion 2.9, deduccion «Puente de Wheatstone» (Ec. 5 y comprobacion numerica)
* Puente de cuatro resistencias de 1 kohm excitado con 5 V; una de ellas varia dR.
* El libro dice: con dR = 1 ohm la salida exacta es 1,2494 mV (aproximacion Vexc/4*dR/R = 1,2500 mV);
*   con dR = 10 ohm, 12,4378 mV frente a 12,5000 mV.
* Ejercicio ej-2.5: con R4 = 1010 ohm el puente se desequilibra (misma cuenta que dR = 10 ohm).
* Ejecutar:  ngspice -b puente_wheatstone.cir
Vexc exc 0 DC 5
* puente equilibrado de referencia
R1 exc a 1k
R2 a 0 1k
R3 exc b 1k
R4 b 0 1k
* puente con dR = 1 ohm en la resistencia inferior de una rama
R1x exc ax 1k
R2x ax 0 1001
R3x exc bx 1k
R4x bx 0 1k
* puente con dR = 10 ohm (ej-2.5: R4 = 1010 ohm)
R1y exc ay 1k
R2y ay 0 1010
R3y exc by 1k
R4y by 0 1k
.control
op
let v0  = v(a) - v(b)
let v1  = 1000*(v(ax) - v(bx))
let v10 = 1000*(v(ay) - v(by))
let aprox1  = 1000*5/4*1/1000
let aprox10 = 1000*5/4*10/1000
let err1  = 100*(aprox1 - v1)/v1
let err10 = 100*(aprox10 - v10)/v10
print v0
print v1 aprox1 err1
print v10 aprox10 err10
.endc
.end
