* prob-17.A (sección 17.12), segundo mecanismo: la corriente de fuga de la entrada (1 uA, máximo
* garantizado por la hoja de datos del ATmega328P) atraviesa la impedancia de la fuente y produce
* un error de tensión estático, que no se promedia.
* Comprueba: 10 mV = 2,0 LSB con 10 kOhm y 100 mV = 20,5 LSB con 100 kOhm (LSB = 5 V/1024).
* Ejecutar: ngspice -b prob-17.A-fuga.cir
VIN in 0 DC 2.5
RS in adc 10k
ILK adc 0 DC 1u
.control
  foreach r 10k 100k
    alter RS = $r
    op
    let drop = 2.5 - v(adc)
    let lsb = drop / (5/1024)
    echo "R_s = $r -> error (V) and (LSB):"
    print drop lsb
  end
.endc
.end
