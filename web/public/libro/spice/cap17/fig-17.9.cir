* fig-17.9 (derecha) y sección 17.5 «El PWM no es una salida analógica»: PWM de Arduino a 490 Hz
* con ciclo de trabajo del 65 % (salida de 0 a 5 V) filtrado con un RC de primer orden.
* Tres filtros: tau = 1 ms (10 kOhm, 100 nF), 10 ms (10 kOhm, 1 uF) y 100 ms (10 kOhm, 10 uF).
* Comprueba: valor medio 3,25 V en todos; rizado pico a pico ~2 V con 1 ms, ~0,23 V con 10 ms y
* ~23 mV (~1 LSB de 8 bits) con 100 ms: por eso el filtro necesita decenas o un centenar de ms.
* Ejecutar: ngspice -b fig-17.9.cir
VPWM p 0 PULSE(0 5 0 1u 1u 1.32653m 2.040816m)
R1 p f1 10k
C1 f1 0 100n
R2 p f2 10k
C2 f2 0 1u
R3 p f3 10k
C3 f3 0 10u
.control
  tran 2u 1.2 0 2u uic
  meas tran avg1 avg v(f1) from=1.1 to=1.2
  meas tran pp1 pp v(f1) from=1.1 to=1.2
  meas tran avg2 avg v(f2) from=1.1 to=1.2
  meas tran pp2 pp v(f2) from=1.1 to=1.2
  meas tran avg3 avg v(f3) from=1.1 to=1.2
  meas tran pp3 pp v(f3) from=1.1 to=1.2
.endc
.end
