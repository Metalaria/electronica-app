* Sección 17.10, «El regulador de a bordo y su límite real»: regulador lineal de 5 V (modelo de
* comportamiento: salida fija de 5 V, la corriente de entrada es la de la carga) con 400 mA de carga.
* Comprueba: P = (Vent - 5 V)·I = 2,8 W con 12 V y 1,0 W con 7,5 V a la entrada del regulador.
* Ejecutar: ngspice -b reg-17.10.cir
VIN in 0 DC 12
* input side: a 0 V source to measure the current; the regulator draws what the load takes
VSENSE in pass DC 0
BIN pass 0 I = i(VOUTS)
* output side: fixed 5 V, current measured by VOUTS
BREG reg 0 V = 5
VOUTS reg out DC 0
ILOAD out 0 DC 0.4
.control
  foreach vsup 12 7.5
    alter VIN dc = $vsup
    op
    let preg = (v(in) - v(out)) * i(VSENSE)
    echo "Vin = $vsup V -> regulator dissipation (W):"
    print v(in) v(out) i(VSENSE) preg
  end
.endc
.end
