* Sección 17.4, «Un pin no es un interruptor ideal»: LED rojo desde una salida de 5 V con 150 Ohm.
* Modelo de LED rojo ajustado para 2,0 V a 20 mA. Primer caso: pin ideal (5 V exactos).
* Segundo caso: pin con su resistencia de salida (la hoja de datos garantiza VOH >= 4,2 V a 20 mA
* con VCC = 5 V, unos 40 Ohm en el peor caso; ~25 Ohm típicos).
* Comprueba: (5 - 2)/150 = 20 mA con el pin ideal; con 25-40 Ohm de salida la corriente baja a unos
* 17-18 mA, dentro de los 20 mA recomendados.
* Ejecutar: ngspice -b led-150.cir
.model LEDR D (IS=3.2e-19 N=2 RS=1)
VPIN pin 0 DC 5
RPIN pin out 1m
R1 out a 150
D1 a 0 LEDR
.control
  foreach ro 1m 25 40
    alter RPIN = $ro
    op
    let iled = -i(VPIN)
    let vled = v(a)
    echo "R_out = $ro ohm -> I_LED (A), V_LED (V):"
    print iled vled
  end
.endc
.end
