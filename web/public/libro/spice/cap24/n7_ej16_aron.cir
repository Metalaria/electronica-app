* Exercise 23.16: balanced load drawing 6 A at cos phi 0.3 (motor at no load); Aron with the common lead on L3
V1 l1 0 AC 230.940108 0
V2 l2 0 AC 230.940108 -120
V3 l3 0 AC 230.940108 120
VA1 l1 a1 DC 0 AC 0
VA2 l2 a2 DC 0 AC 0
VA3 l3 a3 DC 0 AC 0
R1 a1 m1 11.547005
L1 m1 s 0.11687428
R2 a2 m2 11.547005
L2 m2 s 0.11687428
R3 a3 m3 11.547005
L3 m3 s 0.11687428
.ac lin 1 50 50
.end
