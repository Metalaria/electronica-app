* 23.10 example: three 53.33 ohm resistors, star (s) and delta (second set on separate source copy)
V1 l1 0 AC 230.940108 0
V2 l2 0 AC 230.940108 -120
V3 l3 0 AC 230.940108 120
VA1 l1 a1 DC 0 AC 0
R1 a1 s 53.33333
R2 l2 s 53.33333
R3 l3 s 53.33333
VB1 l1 b1 DC 0 AC 0
R12 b1 l2 53.33333
R23 l2 l3 53.33333
R31 l3 b1 53.33333
.ac lin 1 50 50
.end
