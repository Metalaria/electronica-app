* Figura 24.8 (sección 24.4): diagramas fasoriales.
* (a) RC serie de 1 kohm y 100 nF a 1 kHz con 1 mA: V_R = 1,00 V, V_C = 1,59 V, V = 1,88 V a -57,9 grados.
* (b) RLC serie de la práctica 22.9 (R = 100 ohm, L = 10 mH, C = 100 nF) con 1 V a f0 = 5033 Hz:
*     I = 10 mA, Q = 3,16, V_L = V_C = 3,16 V en oposición.
* Ejecutar: ngspice -b fig-24.8.cir
I1 0 a AC 1m
R1 a b 1k
C1 b 0 100n
V2 c 0 AC 1
R2 c d 100
L2 d e 10m
C2 e 0 100n
.ac lin 1 5032.92 5032.92
.control
run
let ir = mag(i(V2))
let vl = mag(v(d)-v(e))
let vcap = mag(v(e))
print ir vl vcap
ac lin 1 1k 1k
let vr = mag(v(a)-v(b))
let vc = mag(v(b))
let v = mag(v(a))
let ang = 180/pi*ph(v(a))
print vr vc v ang
.endc
.end
