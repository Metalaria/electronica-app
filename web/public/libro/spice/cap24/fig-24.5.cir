* Figura 24.5 (sección 24.3): escalón aplicado a un RLC serie, tensión en el condensador.
* L = 10 mH y C = 100 nF (sqrt(L/C) = 316,2 ohm); R se elige para zeta = (R/2)*sqrt(C/L) = 0,2, 1 y 2.
* Comprueba: con zeta = 0,2 el sobreimpulso es exp(-pi*zeta/sqrt(1-zeta^2)) = 52,7 % (la figura dice 53 %);
* con zeta = 1 y zeta = 2 no hay sobreimpulso (el máximo no pasa de 1 V).
* Ejecutar: ngspice -b fig-24.5.cir
V1 in 0 PWL(0 0 1n 1)
* zeta = 0,2
Ra in a1 126.49
La a1 a2 10m
Ca a2 0 100n IC=0
* zeta = 1
Rb in b1 632.46
Lb b1 b2 10m
Cb b2 0 100n IC=0
* zeta = 2
Rc in c1 1264.9
Lc c1 c2 10m
Cc c2 0 100n IC=0
.tran 0.2u 4m UIC
.control
run
meas tran pico_02 MAX v(a2)
meas tran pico_1  MAX v(b2)
meas tran pico_2  MAX v(c2)
let sobre_02 = 100*(pico_02-1)
print sobre_02
.endc
.end
