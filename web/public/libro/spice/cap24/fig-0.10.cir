* Figura 0.10 (sección 24.4, «Un ejemplo con números»): RC serie de 1 kohm y 100 nF a 1 kHz con 1 V eficaz.
* Comprueba: X_C = 1592 ohm, |Z| = 1880 ohm, fase -57,9 grados; I = 0,532 mA adelantada 57,9 grados;
* V_R = 0,532 V y V_C = 0,847 V (0,532^2 + 0,847^2 = 1); paso bajo a -3 dB en 1,59 kHz.
* Ejecutar: ngspice -b fig-0.10.cir
V1 in 0 AC 1
R1 in mid 1k
C1 mid 0 100n
.ac lin 1 1k 1k
.control
run
let zmag = 1/mag(i(V1))
let iang = 180/pi*ph(-i(V1))
let vr = mag(v(in)-v(mid))
let vc = mag(v(mid))
let suma = vr^2 + vc^2
print zmag iang vr vc suma
ac dec 200 10 100k
meas ac f3db WHEN vdb(mid)=-3.0103 FALL=1
.endc
.end
