* Sección 24.9: el transformador en alterna.
* (a) Transformador ideal (fuente controlada E para la tensión y F para la corriente) 10:1 con 8 ohm:
*     el primario ve 800 ohm. (b) Relación 3:1 con 8 ohm (ejercicio 24.8): 72 ohm.
* (c) Bobinas acopladas con L1 = 10 mH, L2 = 1 mH, k = 0,95: con el secundario abierto se mide L1 = 10 mH;
*     con el secundario en cortocircuito, L1*(1 - k^2) = 0,975 mH (9,75 %); de su cociente,
*     k = sqrt(1 - Lcc/Lab) = 0,95.
* Ejecutar: ngspice -b transformador_24.9.cir
* (a) 10:1
Va p1 0 AC 1
Ea s1 0 p1 0 0.1
Vsa s1 s1x 0
Rla s1x 0 8
Fa p1 0 Vsa 0.1
* (b) 3:1
Vb p2 0 AC 1
Eb s2 0 p2 0 0.33333333
Vsb s2 s2x 0
Rlb s2x 0 8
Fb p2 0 Vsb 0.33333333
* (c) acopladas: abierta (L1o/L2o) y en corto (L1c/L2c)
Vc1 q1 0 AC 1
L1o q1 0 10m
L2o q2 0 1m
Ro q2 0 1G
K1 L1o L2o 0.95
Vc2 r1 0 AC 1
L1c r1 0 10m
L2c r2 0 1m
Rc r2 0 1u
K2 L1c L2c 0.95
.ac lin 1 1k 1k
.control
run
let za = 1/mag(i(Va))
let zb = 1/mag(i(Vb))
let lab = 1/(2*pi*1000*mag(i(Vc1)))
let lcc = 1/(2*pi*1000*mag(i(Vc2)))
let k = sqrt(1 - lcc/lab)
print za zb lab lcc k
.endc
.end
