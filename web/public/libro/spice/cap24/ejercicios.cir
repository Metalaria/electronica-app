* Ejercicios del capítulo 24.
* 24.1: RL con L = 10 mH y R = 100 ohm -> tau = 0,1 ms (la corriente llega al 63,2 % en 0,1 ms).
* 24.2: RLC serie R = 10 ohm, L = 1 mH, C = 1 uF -> w0 = 31 623 rad/s (5,03 kHz), zeta = 0,158,
*       subamortiguado: sobreimpulso exp(-pi*zeta/sqrt(1-zeta^2)) = 60,5 %, oscilación a w0*sqrt(1-zeta^2).
* 24.4 y 24.5: 100 uH y 100 pF -> f0 = 1,59 MHz; con Q = 100 (R = 10 ohm), BW = 15,9 kHz
*       (comprobado en resonancia_24.6.cir).
* 24.8: 8 ohm tras un 3:1 -> 72 ohm (comprobado en transformador_24.9.cir).
* Ejecutar: ngspice -b ejercicios.cir
V1 a 0 PWL(0 0 1n 1)
R1 a b 100
L1 b 0 10m IC=0
V2 c 0 PWL(0 0 1n 1)
R2 c d 10
L2 d e 1m IC=0
C2 e 0 1u IC=0
.tran 0.05u 2m UIC
.control
run
let il = i(V1)*(-1)
meas tran t63 WHEN il=6.3212m RISE=1
meas tran pico MAX v(e)
let sobre = 100*(pico-1)
print sobre
meas tran t1 WHEN v(e)=1 CROSS=1
meas tran t3 WHEN v(e)=1 CROSS=3
let fd = 1/(t3-t1)
print fd
.endc
.end
