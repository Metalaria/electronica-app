* Secciones 24.5 y 24.8: carga de 230 V que toma 10 A con factor de potencia 0,8 y su corrección.
* La carga es R = 18,4 ohm en serie con X_L = 13,8 ohm (|Z| = 23 ohm a 36,87 grados) -> L = 43,93 mH a 50 Hz.
* Comprueba: S = 2300 VA, P = 1840 W, Q = 1380 VAr; con 46,6 uF en paralelo (FP 0,95) la corriente
* baja a 8,42 A; con 83 uF (FP 1) baja a 8,00 A, y la potencia activa sigue siendo 1840 W.
* Ejecutar: ngspice -b potencia_24.5.cir
* fuente de 230 V eficaces = 325,27 V de pico; Vs* miden la corriente de cada caso
V1 lin 0 SIN(0 325.269 50)
Vsa lin a 0
Ra a a1 18.4
La a1 0 43.93m
Vsb lin b 0
Rb b b1 18.4
Lb b1 0 43.93m
Cb b 0 46.65u
Vsc lin c 0
Rc c c1 18.4
Lc c1 0 43.93m
Cc c 0 83.04u
.tran 20u 1 0.8 20u
.control
run
meas tran ia RMS i(Vsa) FROM=0.8 TO=1
meas tran ib RMS i(Vsb) FROM=0.8 TO=1
meas tran ic RMS i(Vsc) FROM=0.8 TO=1
let pa_t = v(lin)*i(Vsa)
let pc_t = v(lin)*i(Vsc)
meas tran pa AVG pa_t FROM=0.8 TO=1
meas tran pc AVG pc_t FROM=0.8 TO=1
let s = 230*ia
let fp = pa/s
print s fp
.endc
.end
