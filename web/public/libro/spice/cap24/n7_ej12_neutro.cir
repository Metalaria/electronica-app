* Exercise 23.12: 3 kW, 2 kW and 1 kW resistive on L1, L2, L3 (rated at 230.9 V), neutral current in VN
V1 l1 0 AC 230.940108 0
V2 l2 0 AC 230.940108 -120
V3 l3 0 AC 230.940108 120
R1 l1 s 17.777778
R2 l2 s 26.666667
R3 l3 s 53.333333
VN s 0 DC 0 AC 0
.ac lin 1 50 50
.end
