* Exercise 23.10: Z = 30 + j40 ohm per phase, star (no neutral needed: balanced)
V1 l1 0 AC 230.940108 0
V2 l2 0 AC 230.940108 -120
V3 l3 0 AC 230.940108 120
R1 l1 m1 30
L1 m1 s 0.1273239545
R2 l2 m2 30
L2 m2 s 0.1273239545
R3 l3 m3 30
L3 m3 s 0.1273239545
.ac lin 1 50 50
.end
