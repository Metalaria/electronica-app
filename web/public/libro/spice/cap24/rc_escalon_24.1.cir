* Sección 24.1 (y figuras 24.1 y 24.2): RC de 10 kohm y 100 nF conectado de golpe a 5 V.
* Comprueba: tau = 1 ms; v(tau) = 3,16 V (63,2 %); v(5 tau) = 4,966 V, es decir, falta el 0,674 %;
* para quedar a menos de 1 LSB de 12 bits (1/4096) hacen falta unos 8,3 tau.
* Ejecutar: ngspice -b rc_escalon_24.1.cir
V1 in 0 PWL(0 0 1n 5)
R1 in out 10k
C1 out 0 100n IC=0
.tran 1u 12m UIC
.control
run
meas tran v_tau   FIND v(out) AT=1m
meas tran v_5tau  FIND v(out) AT=5m
let falta5 = 100*(5 - v_5tau)/5
print falta5
meas tran t_12bit WHEN v(out)=4.998779 RISE=1
let n_tau = t_12bit/1m
print n_tau
.endc
.end
