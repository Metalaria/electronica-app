* 23.10: instantaneous power of a balanced load (230 V, 10 A, 30 deg per phase), star with neutral
V1 l1 0 SIN(0 325.2691 50 0 0 90)
V2 l2 0 SIN(0 325.2691 50 0 0 -30)
V3 l3 0 SIN(0 325.2691 50 0 0 210)
VA1 l1 a1 DC 0
VA2 l2 a2 DC 0
VA3 l3 a3 DC 0
R1 a1 m1 19.918584
L1 m1 0 0.03660564
R2 a2 m2 19.918584
L2 m2 0 0.03660564
R3 a3 m3 19.918584
L3 m3 0 0.03660564
.tran 20u 0.1 0 20u
.end
