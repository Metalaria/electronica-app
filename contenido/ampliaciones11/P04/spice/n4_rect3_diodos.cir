* n4_rect3_diodos: three-phase six-pulse bridge, 400 V, alpha=0 deg, Ls=0 mH, load R54, diodes
.model DR D(IS=1e-12 N=1.5 RS=5m)
Va a0 0 SIN(0 326.5986 50 0 0 0)
LSa a0 a 2e-05
Vb b0 0 SIN(0 326.5986 50 0 0 -120)
LSb b0 b 2e-05
Vc c0 0 SIN(0 326.5986 50 0 0 -240)
LSc c0 c 2e-05
D1 a p DR
D3 b p DR
D5 c p DR
D4 n a DR
D6 n b DR
D2 n c DR
VSENSE p p1 0
RL p1 n 54
.options method=gear reltol=1e-3 vntol=1e-4 abstol=1e-9 itl4=100
.tran 5u 80m 0 5u
.save v(p) v(n) v(a) v(b) v(c) i(VSENSE) i(Va)
.end
