* 23.10: three identical single-phase rectifier-capacitor loads (about 300 W each), one per phase,
* returning through the neutral; VN measures the neutral current. Source: 0.5 ohm + 1 mH (damped by 100 ohm)
V1 l1 0 SIN(0 326.5986 50 0 0 90)
V2 l2 0 SIN(0 326.5986 50 0 0 -30)
V3 l3 0 SIN(0 326.5986 50 0 0 210)
RS1 l1 x1 0.5
LS1 x1 y1 1m
RP1 x1 y1 100
D1a y1 p1 DR
D1b n1 n DR
D1c n1 y1 DR
D1d n p1 DR
C1 p1 n1 470u IC=300
RL1 p1 n1 330
RF1 n1 0 100Meg
RS2 l2 x2 0.5
LS2 x2 y2 1m
RP2 x2 y2 100
D2a y2 p2 DR
D2b n2 n DR
D2c n2 y2 DR
D2d n p2 DR
C2 p2 n2 470u IC=300
RL2 p2 n2 330
RF2 n2 0 100Meg
RS3 l3 x3 0.5
LS3 x3 y3 1m
RP3 x3 y3 100
D3a y3 p3 DR
D3b n3 n DR
D3c n3 y3 DR
D3d n p3 DR
C3 p3 n3 470u IC=300
RL3 p3 n3 330
RF3 n3 0 100Meg
VN n 0 DC 0
.options method=gear
.model DR D(IS=4n RS=0.05 N=1.9 CJO=50p)
.tran 10u 0.5 0 10u uic
.end
