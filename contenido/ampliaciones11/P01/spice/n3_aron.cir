* 23.10: two-wattmeter (Aron) method on an unbalanced 3-wire load, transient (instantaneous values)
V1 l1 0 SIN(0 326.5986 50 0 0 90)
V2 l2 0 SIN(0 326.5986 50 0 0 -30)
V3 l3 0 SIN(0 326.5986 50 0 0 210)
VA1 l1 a1 DC 0
VA2 l2 a2 DC 0
VA3 l3 a3 DC 0
R1 a1 s 20
R2 a2 m2 10
L2 m2 s 50m
R3 a3 m3 30
C3 m3 s 100u
.tran 20u 0.2 0 20u
.end
