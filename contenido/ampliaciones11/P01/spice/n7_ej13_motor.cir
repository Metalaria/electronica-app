* Exercise 23.13: 7.5 kW motor (eta 0.88, cos 0.80) plus a delta bank of 23.812 uF per branch
V1 l1 0 AC 230.940108 0
V2 l2 0 AC 230.940108 -120
V3 l3 0 AC 230.940108 120
VA1 l1 a1 DC 0 AC 0
VA2 l2 a2 DC 0 AC 0
VA3 l3 a3 DC 0 AC 0
R1 a1 m1 12.014933
L1 m1 s 0.02868354
R2 a2 m2 12.014933
L2 m2 s 0.02868354
R3 a3 m3 12.014933
L3 m3 s 0.02868354
C12 a1 a2 2.381197e-05
C23 a2 a3 2.381197e-05
C31 a3 a1 2.381197e-05
.ac lin 1 50 50
.end
