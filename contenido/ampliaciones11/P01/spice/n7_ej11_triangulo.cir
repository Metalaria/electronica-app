* Exercise 23.11: the same Z = 30 + j40 ohm in delta; VAk measure the line currents
V1 l1 0 AC 230.940108 0
V2 l2 0 AC 230.940108 -120
V3 l3 0 AC 230.940108 120
VA1 l1 a1 DC 0 AC 0
VA2 l2 a2 DC 0 AC 0
VA3 l3 a3 DC 0 AC 0
R12 a1 m12 30
L12 m12 a2 0.1273239545
R23 a2 m23 30
L23 m23 a3 0.1273239545
R31 a3 m31 30
L31 m31 a1 0.1273239545
.ac lin 1 50 50
.end
