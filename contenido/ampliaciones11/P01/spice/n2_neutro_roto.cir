* 23.10: the same loads with the neutral cut: the star point s floats
V1 l1 0 AC 230.940108 0
V2 l2 0 AC 230.940108 -120
V3 l3 0 AC 230.940108 120
R1 l1 s 26.45
R2 l2 s 52.9
R3 l3 s 264.5
.ac lin 1 50 50
.end
