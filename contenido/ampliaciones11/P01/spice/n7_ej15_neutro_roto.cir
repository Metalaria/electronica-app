* Exercise 23.15: 3 kW, 500 W and 100 W (rated at 230 V) with the neutral cut
V1 l1 0 AC 230.940108 0
V2 l2 0 AC 230.940108 -120
V3 l3 0 AC 230.940108 120
R1 l1 s 17.633333
R2 l2 s 105.800000
R3 l3 s 529.000000
.ac lin 1 50 50
.end
