* P02: DC motor (24 V, 0.5 ohm, k = 0.05, L = 50 uH, J = 1e-4) started direct on line, no load
VA   a 0 PWL(0 0 1u 24)
VSEN a b DC 0
RA   b c 0.5
LA   c d 5e-05
* back emf E = k*w
BE   d 0 V = 0.05*v(w)
* mechanics: J dw/dt = k*i - T_load (node w: 1 V = 1 rad/s)
BT   0 w I = 0.05*i(VSEN)
CJ   w 0 0.0001
.tran 5u 0.15 0 5u uic
.control
run
let rpm = v(w)*60/(2*pi)
meas tran i_pico MAX i(VSEN) from=0 to=5m
meas tran t63 WHEN v(w)=303.4 RISE=1
meas tran w_fin FIND v(w) AT=0.149
meas tran i_20ms FIND i(VSEN) AT=20m
print i_pico t63 w_fin i_20ms
.endc
.end
