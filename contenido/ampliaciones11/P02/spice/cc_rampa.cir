* P02: the same motor started with a 0 -> 24 V ramp in 0.2 s (soft start by PWM), no load
VA   a 0 PWL(0 0 0.2 24)
VSEN a b DC 0
RA   b c 0.5
LA   c d 5e-05
* back emf E = k*w
BE   d 0 V = 0.05*v(w)
* mechanics: J dw/dt = k*i - T_load (node w: 1 V = 1 rad/s)
BT   0 w I = 0.05*i(VSEN)
CJ   w 0 0.0001
.tran 20u 0.4 0 20u uic
.control
run
meas tran i_max MAX i(VSEN) from=0 to=0.2
meas tran i_100ms FIND i(VSEN) AT=0.1
meas tran w_fin FIND v(w) AT=0.399
print i_max i_100ms w_fin
.endc
.end
