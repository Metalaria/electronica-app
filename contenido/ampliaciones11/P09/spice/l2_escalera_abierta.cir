* P09: 1 m of 50 ohm PE coax as 200 LC cells (L=1.250865e-09 H, C=5.003461e-13 F), load abierta
VS s 0 PULSE(0 1 1n 0.5n 0.5n 100n 200n)
RS s in 50
L1 in m1 1.250865e-09
C1 m1 0 5.003461e-13
RX1 m1 n1 1e-6
L2 n1 m2 1.250865e-09
C2 m2 0 5.003461e-13
RX2 m2 n2 1e-6
L3 n2 m3 1.250865e-09
C3 m3 0 5.003461e-13
RX3 m3 n3 1e-6
L4 n3 m4 1.250865e-09
C4 m4 0 5.003461e-13
RX4 m4 n4 1e-6
L5 n4 m5 1.250865e-09
C5 m5 0 5.003461e-13
RX5 m5 n5 1e-6
L6 n5 m6 1.250865e-09
C6 m6 0 5.003461e-13
RX6 m6 n6 1e-6
L7 n6 m7 1.250865e-09
C7 m7 0 5.003461e-13
RX7 m7 n7 1e-6
L8 n7 m8 1.250865e-09
C8 m8 0 5.003461e-13
RX8 m8 n8 1e-6
L9 n8 m9 1.250865e-09
C9 m9 0 5.003461e-13
RX9 m9 n9 1e-6
L10 n9 m10 1.250865e-09
C10 m10 0 5.003461e-13
RX10 m10 n10 1e-6
L11 n10 m11 1.250865e-09
C11 m11 0 5.003461e-13
RX11 m11 n11 1e-6
L12 n11 m12 1.250865e-09
C12 m12 0 5.003461e-13
RX12 m12 n12 1e-6
L13 n12 m13 1.250865e-09
C13 m13 0 5.003461e-13
RX13 m13 n13 1e-6
L14 n13 m14 1.250865e-09
C14 m14 0 5.003461e-13
RX14 m14 n14 1e-6
L15 n14 m15 1.250865e-09
C15 m15 0 5.003461e-13
RX15 m15 n15 1e-6
L16 n15 m16 1.250865e-09
C16 m16 0 5.003461e-13
RX16 m16 n16 1e-6
L17 n16 m17 1.250865e-09
C17 m17 0 5.003461e-13
RX17 m17 n17 1e-6
L18 n17 m18 1.250865e-09
C18 m18 0 5.003461e-13
RX18 m18 n18 1e-6
L19 n18 m19 1.250865e-09
C19 m19 0 5.003461e-13
RX19 m19 n19 1e-6
L20 n19 m20 1.250865e-09
C20 m20 0 5.003461e-13
RX20 m20 n20 1e-6
L21 n20 m21 1.250865e-09
C21 m21 0 5.003461e-13
RX21 m21 n21 1e-6
L22 n21 m22 1.250865e-09
C22 m22 0 5.003461e-13
RX22 m22 n22 1e-6
L23 n22 m23 1.250865e-09
C23 m23 0 5.003461e-13
RX23 m23 n23 1e-6
L24 n23 m24 1.250865e-09
C24 m24 0 5.003461e-13
RX24 m24 n24 1e-6
L25 n24 m25 1.250865e-09
C25 m25 0 5.003461e-13
RX25 m25 n25 1e-6
L26 n25 m26 1.250865e-09
C26 m26 0 5.003461e-13
RX26 m26 n26 1e-6
L27 n26 m27 1.250865e-09
C27 m27 0 5.003461e-13
RX27 m27 n27 1e-6
L28 n27 m28 1.250865e-09
C28 m28 0 5.003461e-13
RX28 m28 n28 1e-6
L29 n28 m29 1.250865e-09
C29 m29 0 5.003461e-13
RX29 m29 n29 1e-6
L30 n29 m30 1.250865e-09
C30 m30 0 5.003461e-13
RX30 m30 n30 1e-6
L31 n30 m31 1.250865e-09
C31 m31 0 5.003461e-13
RX31 m31 n31 1e-6
L32 n31 m32 1.250865e-09
C32 m32 0 5.003461e-13
RX32 m32 n32 1e-6
L33 n32 m33 1.250865e-09
C33 m33 0 5.003461e-13
RX33 m33 n33 1e-6
L34 n33 m34 1.250865e-09
C34 m34 0 5.003461e-13
RX34 m34 n34 1e-6
L35 n34 m35 1.250865e-09
C35 m35 0 5.003461e-13
RX35 m35 n35 1e-6
L36 n35 m36 1.250865e-09
C36 m36 0 5.003461e-13
RX36 m36 n36 1e-6
L37 n36 m37 1.250865e-09
C37 m37 0 5.003461e-13
RX37 m37 n37 1e-6
L38 n37 m38 1.250865e-09
C38 m38 0 5.003461e-13
RX38 m38 n38 1e-6
L39 n38 m39 1.250865e-09
C39 m39 0 5.003461e-13
RX39 m39 n39 1e-6
L40 n39 m40 1.250865e-09
C40 m40 0 5.003461e-13
RX40 m40 n40 1e-6
L41 n40 m41 1.250865e-09
C41 m41 0 5.003461e-13
RX41 m41 n41 1e-6
L42 n41 m42 1.250865e-09
C42 m42 0 5.003461e-13
RX42 m42 n42 1e-6
L43 n42 m43 1.250865e-09
C43 m43 0 5.003461e-13
RX43 m43 n43 1e-6
L44 n43 m44 1.250865e-09
C44 m44 0 5.003461e-13
RX44 m44 n44 1e-6
L45 n44 m45 1.250865e-09
C45 m45 0 5.003461e-13
RX45 m45 n45 1e-6
L46 n45 m46 1.250865e-09
C46 m46 0 5.003461e-13
RX46 m46 n46 1e-6
L47 n46 m47 1.250865e-09
C47 m47 0 5.003461e-13
RX47 m47 n47 1e-6
L48 n47 m48 1.250865e-09
C48 m48 0 5.003461e-13
RX48 m48 n48 1e-6
L49 n48 m49 1.250865e-09
C49 m49 0 5.003461e-13
RX49 m49 n49 1e-6
L50 n49 m50 1.250865e-09
C50 m50 0 5.003461e-13
RX50 m50 n50 1e-6
L51 n50 m51 1.250865e-09
C51 m51 0 5.003461e-13
RX51 m51 n51 1e-6
L52 n51 m52 1.250865e-09
C52 m52 0 5.003461e-13
RX52 m52 n52 1e-6
L53 n52 m53 1.250865e-09
C53 m53 0 5.003461e-13
RX53 m53 n53 1e-6
L54 n53 m54 1.250865e-09
C54 m54 0 5.003461e-13
RX54 m54 n54 1e-6
L55 n54 m55 1.250865e-09
C55 m55 0 5.003461e-13
RX55 m55 n55 1e-6
L56 n55 m56 1.250865e-09
C56 m56 0 5.003461e-13
RX56 m56 n56 1e-6
L57 n56 m57 1.250865e-09
C57 m57 0 5.003461e-13
RX57 m57 n57 1e-6
L58 n57 m58 1.250865e-09
C58 m58 0 5.003461e-13
RX58 m58 n58 1e-6
L59 n58 m59 1.250865e-09
C59 m59 0 5.003461e-13
RX59 m59 n59 1e-6
L60 n59 m60 1.250865e-09
C60 m60 0 5.003461e-13
RX60 m60 n60 1e-6
L61 n60 m61 1.250865e-09
C61 m61 0 5.003461e-13
RX61 m61 n61 1e-6
L62 n61 m62 1.250865e-09
C62 m62 0 5.003461e-13
RX62 m62 n62 1e-6
L63 n62 m63 1.250865e-09
C63 m63 0 5.003461e-13
RX63 m63 n63 1e-6
L64 n63 m64 1.250865e-09
C64 m64 0 5.003461e-13
RX64 m64 n64 1e-6
L65 n64 m65 1.250865e-09
C65 m65 0 5.003461e-13
RX65 m65 n65 1e-6
L66 n65 m66 1.250865e-09
C66 m66 0 5.003461e-13
RX66 m66 n66 1e-6
L67 n66 m67 1.250865e-09
C67 m67 0 5.003461e-13
RX67 m67 n67 1e-6
L68 n67 m68 1.250865e-09
C68 m68 0 5.003461e-13
RX68 m68 n68 1e-6
L69 n68 m69 1.250865e-09
C69 m69 0 5.003461e-13
RX69 m69 n69 1e-6
L70 n69 m70 1.250865e-09
C70 m70 0 5.003461e-13
RX70 m70 n70 1e-6
L71 n70 m71 1.250865e-09
C71 m71 0 5.003461e-13
RX71 m71 n71 1e-6
L72 n71 m72 1.250865e-09
C72 m72 0 5.003461e-13
RX72 m72 n72 1e-6
L73 n72 m73 1.250865e-09
C73 m73 0 5.003461e-13
RX73 m73 n73 1e-6
L74 n73 m74 1.250865e-09
C74 m74 0 5.003461e-13
RX74 m74 n74 1e-6
L75 n74 m75 1.250865e-09
C75 m75 0 5.003461e-13
RX75 m75 n75 1e-6
L76 n75 m76 1.250865e-09
C76 m76 0 5.003461e-13
RX76 m76 n76 1e-6
L77 n76 m77 1.250865e-09
C77 m77 0 5.003461e-13
RX77 m77 n77 1e-6
L78 n77 m78 1.250865e-09
C78 m78 0 5.003461e-13
RX78 m78 n78 1e-6
L79 n78 m79 1.250865e-09
C79 m79 0 5.003461e-13
RX79 m79 n79 1e-6
L80 n79 m80 1.250865e-09
C80 m80 0 5.003461e-13
RX80 m80 n80 1e-6
L81 n80 m81 1.250865e-09
C81 m81 0 5.003461e-13
RX81 m81 n81 1e-6
L82 n81 m82 1.250865e-09
C82 m82 0 5.003461e-13
RX82 m82 n82 1e-6
L83 n82 m83 1.250865e-09
C83 m83 0 5.003461e-13
RX83 m83 n83 1e-6
L84 n83 m84 1.250865e-09
C84 m84 0 5.003461e-13
RX84 m84 n84 1e-6
L85 n84 m85 1.250865e-09
C85 m85 0 5.003461e-13
RX85 m85 n85 1e-6
L86 n85 m86 1.250865e-09
C86 m86 0 5.003461e-13
RX86 m86 n86 1e-6
L87 n86 m87 1.250865e-09
C87 m87 0 5.003461e-13
RX87 m87 n87 1e-6
L88 n87 m88 1.250865e-09
C88 m88 0 5.003461e-13
RX88 m88 n88 1e-6
L89 n88 m89 1.250865e-09
C89 m89 0 5.003461e-13
RX89 m89 n89 1e-6
L90 n89 m90 1.250865e-09
C90 m90 0 5.003461e-13
RX90 m90 n90 1e-6
L91 n90 m91 1.250865e-09
C91 m91 0 5.003461e-13
RX91 m91 n91 1e-6
L92 n91 m92 1.250865e-09
C92 m92 0 5.003461e-13
RX92 m92 n92 1e-6
L93 n92 m93 1.250865e-09
C93 m93 0 5.003461e-13
RX93 m93 n93 1e-6
L94 n93 m94 1.250865e-09
C94 m94 0 5.003461e-13
RX94 m94 n94 1e-6
L95 n94 m95 1.250865e-09
C95 m95 0 5.003461e-13
RX95 m95 n95 1e-6
L96 n95 m96 1.250865e-09
C96 m96 0 5.003461e-13
RX96 m96 n96 1e-6
L97 n96 m97 1.250865e-09
C97 m97 0 5.003461e-13
RX97 m97 n97 1e-6
L98 n97 m98 1.250865e-09
C98 m98 0 5.003461e-13
RX98 m98 n98 1e-6
L99 n98 m99 1.250865e-09
C99 m99 0 5.003461e-13
RX99 m99 n99 1e-6
L100 n99 m100 1.250865e-09
C100 m100 0 5.003461e-13
RX100 m100 n100 1e-6
L101 n100 m101 1.250865e-09
C101 m101 0 5.003461e-13
RX101 m101 n101 1e-6
L102 n101 m102 1.250865e-09
C102 m102 0 5.003461e-13
RX102 m102 n102 1e-6
L103 n102 m103 1.250865e-09
C103 m103 0 5.003461e-13
RX103 m103 n103 1e-6
L104 n103 m104 1.250865e-09
C104 m104 0 5.003461e-13
RX104 m104 n104 1e-6
L105 n104 m105 1.250865e-09
C105 m105 0 5.003461e-13
RX105 m105 n105 1e-6
L106 n105 m106 1.250865e-09
C106 m106 0 5.003461e-13
RX106 m106 n106 1e-6
L107 n106 m107 1.250865e-09
C107 m107 0 5.003461e-13
RX107 m107 n107 1e-6
L108 n107 m108 1.250865e-09
C108 m108 0 5.003461e-13
RX108 m108 n108 1e-6
L109 n108 m109 1.250865e-09
C109 m109 0 5.003461e-13
RX109 m109 n109 1e-6
L110 n109 m110 1.250865e-09
C110 m110 0 5.003461e-13
RX110 m110 n110 1e-6
L111 n110 m111 1.250865e-09
C111 m111 0 5.003461e-13
RX111 m111 n111 1e-6
L112 n111 m112 1.250865e-09
C112 m112 0 5.003461e-13
RX112 m112 n112 1e-6
L113 n112 m113 1.250865e-09
C113 m113 0 5.003461e-13
RX113 m113 n113 1e-6
L114 n113 m114 1.250865e-09
C114 m114 0 5.003461e-13
RX114 m114 n114 1e-6
L115 n114 m115 1.250865e-09
C115 m115 0 5.003461e-13
RX115 m115 n115 1e-6
L116 n115 m116 1.250865e-09
C116 m116 0 5.003461e-13
RX116 m116 n116 1e-6
L117 n116 m117 1.250865e-09
C117 m117 0 5.003461e-13
RX117 m117 n117 1e-6
L118 n117 m118 1.250865e-09
C118 m118 0 5.003461e-13
RX118 m118 n118 1e-6
L119 n118 m119 1.250865e-09
C119 m119 0 5.003461e-13
RX119 m119 n119 1e-6
L120 n119 m120 1.250865e-09
C120 m120 0 5.003461e-13
RX120 m120 n120 1e-6
L121 n120 m121 1.250865e-09
C121 m121 0 5.003461e-13
RX121 m121 n121 1e-6
L122 n121 m122 1.250865e-09
C122 m122 0 5.003461e-13
RX122 m122 n122 1e-6
L123 n122 m123 1.250865e-09
C123 m123 0 5.003461e-13
RX123 m123 n123 1e-6
L124 n123 m124 1.250865e-09
C124 m124 0 5.003461e-13
RX124 m124 n124 1e-6
L125 n124 m125 1.250865e-09
C125 m125 0 5.003461e-13
RX125 m125 n125 1e-6
L126 n125 m126 1.250865e-09
C126 m126 0 5.003461e-13
RX126 m126 n126 1e-6
L127 n126 m127 1.250865e-09
C127 m127 0 5.003461e-13
RX127 m127 n127 1e-6
L128 n127 m128 1.250865e-09
C128 m128 0 5.003461e-13
RX128 m128 n128 1e-6
L129 n128 m129 1.250865e-09
C129 m129 0 5.003461e-13
RX129 m129 n129 1e-6
L130 n129 m130 1.250865e-09
C130 m130 0 5.003461e-13
RX130 m130 n130 1e-6
L131 n130 m131 1.250865e-09
C131 m131 0 5.003461e-13
RX131 m131 n131 1e-6
L132 n131 m132 1.250865e-09
C132 m132 0 5.003461e-13
RX132 m132 n132 1e-6
L133 n132 m133 1.250865e-09
C133 m133 0 5.003461e-13
RX133 m133 n133 1e-6
L134 n133 m134 1.250865e-09
C134 m134 0 5.003461e-13
RX134 m134 n134 1e-6
L135 n134 m135 1.250865e-09
C135 m135 0 5.003461e-13
RX135 m135 n135 1e-6
L136 n135 m136 1.250865e-09
C136 m136 0 5.003461e-13
RX136 m136 n136 1e-6
L137 n136 m137 1.250865e-09
C137 m137 0 5.003461e-13
RX137 m137 n137 1e-6
L138 n137 m138 1.250865e-09
C138 m138 0 5.003461e-13
RX138 m138 n138 1e-6
L139 n138 m139 1.250865e-09
C139 m139 0 5.003461e-13
RX139 m139 n139 1e-6
L140 n139 m140 1.250865e-09
C140 m140 0 5.003461e-13
RX140 m140 n140 1e-6
L141 n140 m141 1.250865e-09
C141 m141 0 5.003461e-13
RX141 m141 n141 1e-6
L142 n141 m142 1.250865e-09
C142 m142 0 5.003461e-13
RX142 m142 n142 1e-6
L143 n142 m143 1.250865e-09
C143 m143 0 5.003461e-13
RX143 m143 n143 1e-6
L144 n143 m144 1.250865e-09
C144 m144 0 5.003461e-13
RX144 m144 n144 1e-6
L145 n144 m145 1.250865e-09
C145 m145 0 5.003461e-13
RX145 m145 n145 1e-6
L146 n145 m146 1.250865e-09
C146 m146 0 5.003461e-13
RX146 m146 n146 1e-6
L147 n146 m147 1.250865e-09
C147 m147 0 5.003461e-13
RX147 m147 n147 1e-6
L148 n147 m148 1.250865e-09
C148 m148 0 5.003461e-13
RX148 m148 n148 1e-6
L149 n148 m149 1.250865e-09
C149 m149 0 5.003461e-13
RX149 m149 n149 1e-6
L150 n149 m150 1.250865e-09
C150 m150 0 5.003461e-13
RX150 m150 n150 1e-6
L151 n150 m151 1.250865e-09
C151 m151 0 5.003461e-13
RX151 m151 n151 1e-6
L152 n151 m152 1.250865e-09
C152 m152 0 5.003461e-13
RX152 m152 n152 1e-6
L153 n152 m153 1.250865e-09
C153 m153 0 5.003461e-13
RX153 m153 n153 1e-6
L154 n153 m154 1.250865e-09
C154 m154 0 5.003461e-13
RX154 m154 n154 1e-6
L155 n154 m155 1.250865e-09
C155 m155 0 5.003461e-13
RX155 m155 n155 1e-6
L156 n155 m156 1.250865e-09
C156 m156 0 5.003461e-13
RX156 m156 n156 1e-6
L157 n156 m157 1.250865e-09
C157 m157 0 5.003461e-13
RX157 m157 n157 1e-6
L158 n157 m158 1.250865e-09
C158 m158 0 5.003461e-13
RX158 m158 n158 1e-6
L159 n158 m159 1.250865e-09
C159 m159 0 5.003461e-13
RX159 m159 n159 1e-6
L160 n159 m160 1.250865e-09
C160 m160 0 5.003461e-13
RX160 m160 n160 1e-6
L161 n160 m161 1.250865e-09
C161 m161 0 5.003461e-13
RX161 m161 n161 1e-6
L162 n161 m162 1.250865e-09
C162 m162 0 5.003461e-13
RX162 m162 n162 1e-6
L163 n162 m163 1.250865e-09
C163 m163 0 5.003461e-13
RX163 m163 n163 1e-6
L164 n163 m164 1.250865e-09
C164 m164 0 5.003461e-13
RX164 m164 n164 1e-6
L165 n164 m165 1.250865e-09
C165 m165 0 5.003461e-13
RX165 m165 n165 1e-6
L166 n165 m166 1.250865e-09
C166 m166 0 5.003461e-13
RX166 m166 n166 1e-6
L167 n166 m167 1.250865e-09
C167 m167 0 5.003461e-13
RX167 m167 n167 1e-6
L168 n167 m168 1.250865e-09
C168 m168 0 5.003461e-13
RX168 m168 n168 1e-6
L169 n168 m169 1.250865e-09
C169 m169 0 5.003461e-13
RX169 m169 n169 1e-6
L170 n169 m170 1.250865e-09
C170 m170 0 5.003461e-13
RX170 m170 n170 1e-6
L171 n170 m171 1.250865e-09
C171 m171 0 5.003461e-13
RX171 m171 n171 1e-6
L172 n171 m172 1.250865e-09
C172 m172 0 5.003461e-13
RX172 m172 n172 1e-6
L173 n172 m173 1.250865e-09
C173 m173 0 5.003461e-13
RX173 m173 n173 1e-6
L174 n173 m174 1.250865e-09
C174 m174 0 5.003461e-13
RX174 m174 n174 1e-6
L175 n174 m175 1.250865e-09
C175 m175 0 5.003461e-13
RX175 m175 n175 1e-6
L176 n175 m176 1.250865e-09
C176 m176 0 5.003461e-13
RX176 m176 n176 1e-6
L177 n176 m177 1.250865e-09
C177 m177 0 5.003461e-13
RX177 m177 n177 1e-6
L178 n177 m178 1.250865e-09
C178 m178 0 5.003461e-13
RX178 m178 n178 1e-6
L179 n178 m179 1.250865e-09
C179 m179 0 5.003461e-13
RX179 m179 n179 1e-6
L180 n179 m180 1.250865e-09
C180 m180 0 5.003461e-13
RX180 m180 n180 1e-6
L181 n180 m181 1.250865e-09
C181 m181 0 5.003461e-13
RX181 m181 n181 1e-6
L182 n181 m182 1.250865e-09
C182 m182 0 5.003461e-13
RX182 m182 n182 1e-6
L183 n182 m183 1.250865e-09
C183 m183 0 5.003461e-13
RX183 m183 n183 1e-6
L184 n183 m184 1.250865e-09
C184 m184 0 5.003461e-13
RX184 m184 n184 1e-6
L185 n184 m185 1.250865e-09
C185 m185 0 5.003461e-13
RX185 m185 n185 1e-6
L186 n185 m186 1.250865e-09
C186 m186 0 5.003461e-13
RX186 m186 n186 1e-6
L187 n186 m187 1.250865e-09
C187 m187 0 5.003461e-13
RX187 m187 n187 1e-6
L188 n187 m188 1.250865e-09
C188 m188 0 5.003461e-13
RX188 m188 n188 1e-6
L189 n188 m189 1.250865e-09
C189 m189 0 5.003461e-13
RX189 m189 n189 1e-6
L190 n189 m190 1.250865e-09
C190 m190 0 5.003461e-13
RX190 m190 n190 1e-6
L191 n190 m191 1.250865e-09
C191 m191 0 5.003461e-13
RX191 m191 n191 1e-6
L192 n191 m192 1.250865e-09
C192 m192 0 5.003461e-13
RX192 m192 n192 1e-6
L193 n192 m193 1.250865e-09
C193 m193 0 5.003461e-13
RX193 m193 n193 1e-6
L194 n193 m194 1.250865e-09
C194 m194 0 5.003461e-13
RX194 m194 n194 1e-6
L195 n194 m195 1.250865e-09
C195 m195 0 5.003461e-13
RX195 m195 n195 1e-6
L196 n195 m196 1.250865e-09
C196 m196 0 5.003461e-13
RX196 m196 n196 1e-6
L197 n196 m197 1.250865e-09
C197 m197 0 5.003461e-13
RX197 m197 n197 1e-6
L198 n197 m198 1.250865e-09
C198 m198 0 5.003461e-13
RX198 m198 n198 1e-6
L199 n198 m199 1.250865e-09
C199 m199 0 5.003461e-13
RX199 m199 n199 1e-6
L200 n199 m200 1.250865e-09
C200 m200 0 5.003461e-13
RX200 m200 out 1e-6
RL out 0 1e9
.tran 10p 30n 0 10p
.end
