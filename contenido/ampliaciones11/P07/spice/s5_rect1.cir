* Single-phase bridge with 220 uF bus, 500 W load; insulation fault DC+ to the case through 1k; TT earth
V1 lv nt SIN(0 325.27 50)
RB nt 0 2
VL lv l 0
VN nt n 0
RS l l1 0.5
D1 l1 p DX
D2 n p DX
D3 m l1 DX
D4 m n DX
C1 p m 220u
RLOAD p m 180
RF p pe 1k
VF pe pe2 0
RA pe2 0 20
.model DX D(IS=1e-9 N=1.5 RS=0.02 CJO=20p)
.options method=gear
.tran 20u 0.3 0 20u
.end
