* TN-S fault: loop = network 0.2 + phase conductor 0.2 + protective conductor 0.2 ohm
V1 s 0 AC 230 0
RRED s l1 0.2
RL l1 l2 0.2
RF l2 m 1u
VPE m m2 0
RPE m2 0 0.2
.ac lin 1 50 50
.end
