* Bench leakage: line-to-earth Y capacitors, 25.1 nF in total (each is in parallel)
V1 l 0 AC 230 0
VF l l2 0
C1 l2 0 4.7n
C2 l2 0 2.2n
C3 l2 0 2.2n
C4 l2 0 4.7n
C5 l2 0 4.7n
C6 l2 0 2.2n
C7 l2 0 2.2n
C8 l2 0 2.2n
.ac lin 1 50 50
.end
