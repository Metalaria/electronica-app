* IT island, second fault: conductor b earthed (scope ground clip); person a-earth 1 kohm
V1 a b AC 230 0
CA a 0 22n
CB b 0 22n
RCLIP b 0 10m
VP a ap 0
RP ap 0 1k
.ac lin 1 50 50
.end
