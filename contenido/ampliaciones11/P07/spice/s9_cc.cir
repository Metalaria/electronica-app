* Short circuit at the bench end: network loop 0.30 ohm, cable loop 0.4774 ohm (70 C)
V1 a 0 AC 230 0
RRED a b 0.30
RLF b c 0.2387018
VCC c d 0
RLN d 0 0.2387018
.ac lin 1 50 50
.end
