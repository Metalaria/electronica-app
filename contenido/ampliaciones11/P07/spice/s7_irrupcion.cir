* Bench inrush: four rectifier front ends switched on together at the voltage peak (cold NTCs)
* network loop |Z| = 0.30 ohm at 45 deg (0.2121 ohm + 0.675 mH) + cable loop 0.399 ohm (25 m of 2.5 mm2 at 20 C)
V1 s 0 SIN(0 325.27 50 0 0 90)
VT s a 0
RRED a a0 0.6111
LRED a0 b 0.675m
* PC: NTC 5 ohm, 330 uF
R1 b a1 5
D11 a1 p1 DX
D12 0 p1 DX
D13 m1 a1 DX
D14 m1 0 DX
C1 p1 m1 330u
* lab supply: NTC 5 ohm, 220 uF
R2 b a2 5
D21 a2 p2 DX
D22 0 p2 DX
D23 m2 a2 DX
D24 m2 0 DX
C2 p2 m2 220u
* oscilloscope: NTC 10 ohm, 100 uF
R3 b a3 10
D31 a3 p3 DX
D32 0 p3 DX
D33 m3 a3 DX
D34 m3 0 DX
C3 p3 m3 100u
* charger without NTC: 1 ohm (wiring + ESR), 47 uF
R4 b a4 1
D41 a4 p4 DX
D42 0 p4 DX
D43 m4 a4 DX
D44 m4 0 DX
C4 p4 m4 47u
.model DX D(IS=1e-9 N=1.5 RS=0.02 CJO=20p)
.options method=gear
.tran 2u 0.04 0 2u uic
.end
