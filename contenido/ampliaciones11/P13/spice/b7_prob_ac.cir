* P13: problem 43.D: same, bias 680 ohm, AC terminations 120 ohm + 1 nF
VCC vcc 0 DC 5.0
VR vr 0 DC 2.5
RUP vcc b 680
RDN a 0 680
RT1 b t1 120
CT1 t1 a 1n
RT2 b t2 120
CT2 t2 a 1n
RUA a vr 459.33
RUB b vr 459.33
.op
.end
