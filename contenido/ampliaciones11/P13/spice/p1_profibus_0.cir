* P13: PROFIBUS segment, active termination at both ends, 0 unit loads
VP vp 0 DC 5
VR vr 0 DC 2.5
RU1 vp b 390
RM1 b a 220
RD1 a 0 390
RU2 vp b 390
RM2 b a 220
RD2 a 0 390
.op
.end
