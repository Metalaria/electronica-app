* P13: problem 43.D: 26 1-UL receivers + one 1/8 UL, bias 680 ohm
VCC vcc 0 DC 5.0
VR vr 0 DC 2.5
RUP vcc b 680
RDN a 0 680
RT1 b a 120
RT2 b a 120
RUA a vr 459.33
RUB b vr 459.33
.op
.end
