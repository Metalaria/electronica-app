* P06 B3: the motor circuit with L = 10 uH (electrical time constant 20 us): a stiff model; no load step needed
V1 va 0 PWL(0 0 1u 24)

R1 va a 0.5
L1 a b 1e-05
VI b c 0
E1 c 0 w 0 0.05
F1 0 w VI 0.05
CJ w 0 0.0005
RB w 0 50000
IL w 0 PWL(0 0 0.5 0 0.500001 0.1)

.options reltol=1e-4
.tran 1m 0.5 uic
.end
