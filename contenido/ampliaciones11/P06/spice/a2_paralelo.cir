* P06 A2: the same system as a parallel RLC (force-current, mobility): C = m, R = 1/b, L = 1/k
* 1 A <-> 1 N, 1 V <-> 1 m/s: v(v) is the velocity of the mass, i(vl) the spring force k x
I1 0 v PWL(0 0 1u 10)
C1 v 0 0.5
R1 v 0 0.25
L1 v l 5m
VL l 0 0
.options reltol=1e-6 abstol=1e-12 vntol=1e-9
.tran 0.5m 1.5 uic
.end
