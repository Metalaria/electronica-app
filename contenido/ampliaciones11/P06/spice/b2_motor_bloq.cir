* P06 B2: the same motor as a block diagram: I = 1/(L s + R) (V - k w), w = 1/(J s + B) (k I - TL)
V1 va 0 PWL(0 0 1u 24)
VT tl 0 PWL(0 0 0.5 0 0.500001 0.1)
* sums (B voltage sources)
Bea ea 0 V=V(va)-0.05*V(w)
Bem em 0 V=0.05*V(i)-V(tl)
* blocks 1/(L s + R) and 1/(J s + B) as first-order lags k/(tau s + 1): C dx/dt = k u - x, C = tau
Bi 0 i I=2*V(ea)-V(i)
Ci i 0 0.002
Bw 0 w I=50000*V(em)-V(w)
Cw w 0 25
.options reltol=1e-6 abstol=1e-12 vntol=1e-9
.tran 0.1m 1 uic
.end
