* P06 E: PI speed loop, Kp = 1.5993 V/(rad/s), Ti = 97.568 ms, reference 200 rad/s at t = 0,
* load 0.1 N m at 0.3 s; mode sat; motor as bloques
Vr r 0 PWL(0 0 1u 200)
Be e 0 V=V(r)-V(w)
* integral of the error: q (1 F capacitor, 1 TOhm to ground for the operating point)
Bq 0 q I=V(e)
Cq q 0 1
Rq q 0 1e12
Bu u 0 V=1.59929969303*(V(e)+V(q)/0.0975678734366)
Bv va 0 V=min(max(V(u),-24),24)

VT tl 0 PWL(0 0 0.3 0 0.300001 0.1)
Bea ea 0 V=V(va)-0.05*V(w)
Bem em 0 V=0.05*V(i)-V(tl)
Bi 0 i I=2*V(ea)-V(i)
Ci i 0 0.002
Bw 0 w I=50000*V(em)-V(w)
Cw w 0 25

.options reltol=1e-6 abstol=1e-12 vntol=1e-9
.tran 0.05m 0.6 uic
.end
