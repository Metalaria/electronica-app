* P06 A1: m = 0.5 kg, b = 4 N s/m, k = 200 N/m as a series RLC (force-voltage): L = m, R = b, C = 1/k
* 1 V <-> 1 N, 1 A <-> 1 m/s, 1 C <-> 1 m: v(c) is the spring force k x, the charge C v(c) the position x
V1 f 0 PWL(0 0 1u 10)
R1 f a 4
L1 a b 0.5
C1 b 0 5m
.options reltol=1e-6 abstol=1e-12 vntol=1e-9
.tran 0.5m 1.5 uic
.end
