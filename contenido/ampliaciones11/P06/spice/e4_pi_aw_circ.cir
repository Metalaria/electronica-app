* P06 E: PI speed loop, Kp = 1.5993 V/(rad/s), Ti = 97.568 ms, reference 200 rad/s at t = 0,
* load 0.1 N m at 0.3 s; mode aw; motor as circuito
Vr r 0 PWL(0 0 1u 200)
Be e 0 V=V(r)-V(w)
* integral of the error: q (1 F capacitor, 1 TOhm to ground for the operating point)
Bq 0 q I=((V(u) > 24 && V(e) > 0) || (V(u) < -24 && V(e) < 0)) ? 0 : V(e)
Cq q 0 1
Rq q 0 1e12
Bu u 0 V=1.59929969303*(V(e)+V(q)/0.0975678734366)
Bv va 0 V=min(max(V(u),-24),24)

R1 va a 0.5
L1 a b 0.001
VI b c 0
E1 c 0 w 0 0.05
F1 0 w VI 0.05
CJ w 0 0.0005
RB w 0 50000
IL w 0 PWL(0 0 0.3 0 0.300001 0.1)

.options reltol=1e-6 abstol=1e-12 vntol=1e-9
.tran 0.05m 0.6 uic
.end
