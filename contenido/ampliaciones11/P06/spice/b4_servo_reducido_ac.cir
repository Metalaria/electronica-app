* P06 B4: open-loop gain of the lead-compensated servo of 30.12: 10 (1 + s/wz)/(1 + s/wp) theta/V,
* theta = w/(2 s); motor reduced (1/k)/(tau_m s + 1)
Vu u 0 DC 0 AC 1
* lead network as 10 [r + (1 - r)/(1 + s/wp)]
Bx 0 x I=V(u)-V(x)
Cx x 0 0.00936
Bva va 0 V=51.6666666667*V(u)+-41.6666666667*V(x)

Bw 0 w I=20*V(va)-V(w)
Cw w 0 0.1

* theta = w/(N s), N = 2
Bth 0 th I=0.5*V(w)
Cth th 0 1
Rth th 0 1e12
.ac dec 400 1 1000
.end
