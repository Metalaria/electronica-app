* Diode with a resistor: 5 V, 1 kOhm (the Newton-Raphson example)
V1 1 0 5
R1 1 2 1k
D1 2 0 dlibro
.options tnom=26.85
.temp 26.85
.model dlibro d(is=1e-12 n=1)
.op
.end
