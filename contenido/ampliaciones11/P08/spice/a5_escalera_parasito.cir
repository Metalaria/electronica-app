* Two-stage ladder fed by a 50 ohm generator with 100 pF at its input node (stiff: 5 ns and 26 ms)
V1 g 0 1
Rg g in 50
Cp in 0 100p
R1 in 1 10k
C1 1 0 1u
R2 1 2 10k
C2 2 0 1u
.tran 0.1m 100m uic
.end
