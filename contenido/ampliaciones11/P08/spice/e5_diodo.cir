* Exercise: diode with a resistor, 2 V and 100 ohm
V1 1 0 2
R1 1 2 100
D1 2 0 dlibro
.options tnom=26.85
.temp 26.85
.model dlibro d(is=1e-12 n=1)
.op
.end
