* Node 3 has no DC path to ground: it sits between two capacitors
V1 1 0 5
R1 1 2 1k
C1 2 3 1u
R2 3 4 1k
C2 4 0 1u
.op
.end
