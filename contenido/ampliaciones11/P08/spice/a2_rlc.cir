* Series RLC of section 0.8 (10 ohm, 1 mH, 1 uF): natural response from vC = 1 V
R1 1 2 10
L1 2 3 1m ic=0
C1 3 1 1u ic=1
Rref 1 0 1G
.options reltol=1e-6 abstol=1e-15 vntol=1e-9
.tran 0.1u 1m 0 0.1u uic
.end
