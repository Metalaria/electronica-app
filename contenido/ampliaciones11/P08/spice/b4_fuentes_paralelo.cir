* Two ideal voltage sources of different value in parallel
V1 1 0 5
V2 1 0 6
R1 1 0 1k
.op
.end
