* Nodal example: 10 mA into node 1, R4 = 1e-15 between nodes 2 and 3
I1 0 1 10m
R1 1 0 1k
R2 1 2 2k
R3 2 0 2k
R4 2 3 1e-15
R5 3 0 1k
.op
.end
