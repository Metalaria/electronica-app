* Exercise: nonlinear RC. 5 V step through 1 kOhm into 1 uF with the diode across the capacitor
V1 in 0 5
R1 in 1 1k
C1 1 0 1u
D1 1 0 dlibro
.options tnom=26.85
.temp 26.85
.model dlibro d(is=1e-12 n=1)
.options reltol=1e-6 abstol=1e-15 vntol=1e-9
.tran 0.5u 2m 0 0.5u uic
.end
