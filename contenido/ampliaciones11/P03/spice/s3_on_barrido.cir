* P03: two-wire sensor ON (7 V drop) into a 4.7 kohm input with a 10 kohm bleeder; supply 19..30 V
V24 p 0 DC 24
VSENS p in DC 7
RIN in 0 4.7k
RP in 0 10k
.dc V24 19 30 0.5
.end
