* P03: two-wire sensor OFF (1.5 mA residual) into a 4.7 kohm input with a 10 kohm bleeder
V24 p 0 DC 24
ISENS p in DC 1.5m
RIN in 0 4.7k
RP in 0 10k
.op
.end
