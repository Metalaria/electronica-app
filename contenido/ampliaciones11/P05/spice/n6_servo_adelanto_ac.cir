* Open loop of the lead-compensated servo (network fed with -x)
V1 x 0 AC 1
Bn xn 0 V=-V(x)
R1 xn n 100k
R3 xn m 24k
C1 m n 390n
R2 n o 100k
Eop o 0 0 n 1e6
Bx1 0 x1 I=100*V(o)
Cx1 x1 0 1
Rx1 x1 0 1e12
Bx2 0 x2 I=1*V(x1)-V(x2)
Cx2 x2 0 0.1
By y 0 V=V(x2)
.ac dec 2000 0.1 10k
.end
