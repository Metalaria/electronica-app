* Closed loop 100/((s+1)(s+3)(s+10)) with a pure delay Tmax = 0.458479 s (matched line)
V1 r 0 PWL(0 0 1u 1)
Be e 0 V=V(r)-V(yd)
Bx1 0 x1 I=3.33333333333*V(e)-V(x1)
Cx1 x1 0 1
Bx2 0 x2 I=1*V(x1)-V(x2)
Cx2 x2 0 0.333333333333
Bx3 0 x3 I=1*V(x2)-V(x3)
Cx3 x3 0 0.1
By y 0 V=V(x3)
Ea a 0 y 0 1
Rs a b 50
T1 b 0 c 0 Z0=50 TD=0.458478676
Rl c 0 50
Ed yd 0 c 0 2
.options reltol=1e-6 abstol=1e-12 vntol=1e-9
.tran 1m 40 0 1m
.end
