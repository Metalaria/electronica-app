* Position servo, K = 10, op-amp lead network (fed with y - r: output is C(s)(r - y))
V1 r 0 PWL(0 0 1u 1)
Bx xe 0 V=V(y)-V(r)
R1 xe n 100k
R3 xe m 24k
C1 m n 390n
R2 n o 100k
Eop o 0 0 n 1e6
Bx1 0 x1 I=100*V(o)
Cx1 x1 0 1
Rx1 x1 0 1e12
Bx2 0 x2 I=1*V(x1)-V(x2)
Cx2 x2 0 0.1
By y 0 V=V(x2)
.options reltol=1e-6 abstol=1e-12 vntol=1e-9
.tran 20u 2 0 20u
.end
