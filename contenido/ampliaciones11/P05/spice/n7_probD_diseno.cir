* Problem 30.D: series PID Kc = 133.7474, Ti' = 1 s, Td' = 1/3 s, N = 10, on 1/((s+1)(s+3)(s+10)), unit step
V1 r 0 PWL(0 0 1u 1)
Be e 0 V=V(r)-V(y)
Bx1 0 x1 I=133.747416006*V(e)
Cx1 x1 0 1
Rx1 x1 0 1e12
Bs2 s2 0 V=(133.747416006)*V(e)+(1)*V(x1)
Bx3 0 x3 I=1*V(s2)-V(x3)
Cx3 x3 0 0.0333333333333
Bs4 s4 0 V=(10)*V(s2)+(-9)*V(x3)
Bx5 0 x5 I=0.0333333333333*V(s4)-V(x5)
Cx5 x5 0 1
Bx6 0 x6 I=1*V(x5)-V(x6)
Cx6 x6 0 0.333333333333
Bx7 0 x7 I=1*V(x6)-V(x7)
Cx7 x7 0 0.1
By y 0 V=V(x7)
.options reltol=1e-6 abstol=1e-12 vntol=1e-9
.tran 0.2m 10 0 0.2m
.end
