* Type II error amplifier of section 32.16: R1 10k; C1 13n in series with R2 40k; C2 360p
V1 x 0 AC 1
R1 x n 10k
R2 n k 40k
C1 k o 13n
C2 n o 360p
Eop o 0 0 n 1e6
.ac dec 2000 10 1meg
.end
