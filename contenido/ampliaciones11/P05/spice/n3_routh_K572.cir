* Loop K/((s+1)(s+3)(s+10)), K = 572, unit step (Routh: stable for K < 572)
V1 r 0 PWL(0 0 1u 1)
Be e 0 V=V(r)-V(y)
Bx1 0 x1 I=19.0666666667*V(e)-V(x1)
Cx1 x1 0 1
Bx2 0 x2 I=1*V(x1)-V(x2)
Cx2 x2 0 0.333333333333
Bx3 0 x3 I=1*V(x2)-V(x3)
Cx3 x3 0 0.1
By y 0 V=V(x3)
.options reltol=1e-6 abstol=1e-12 vntol=1e-9
.tran 0.5m 20 0 0.5m
.end
