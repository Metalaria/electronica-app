* Open loop with the delay line: L(jw) e^(-jw Tmax)
V1 x 0 AC 1
Bx1 0 x1 I=3.33333333333*V(x)-V(x1)
Cx1 x1 0 1
Bx2 0 x2 I=1*V(x1)-V(x2)
Cx2 x2 0 0.333333333333
Bx3 0 x3 I=1*V(x2)-V(x3)
Cx3 x3 0 0.1
By y 0 V=V(x3)
Ea a 0 y 0 1
Rs a b 50
T1 b 0 c 0 Z0=50 TD=0.458478676
Rl c 0 50
Ed yd 0 c 0 2
.ac dec 2000 0.1 100
.end
