* Exercise 30.14: open loop 40/(s (s+2)(s+5)), AC sweep
V1 x 0 AC 1
Bx1 0 x1 I=4*V(x)
Cx1 x1 0 1
Rx1 x1 0 1e12
Bx2 0 x2 I=1*V(x1)-V(x2)
Cx2 x2 0 0.5
Bx3 0 x3 I=1*V(x2)-V(x3)
Cx3 x3 0 0.2
By y 0 V=V(x3)
.ac dec 2000 0.01 100
.end
