* Position servo, K = 10, lag (1 + s/0.70021)/(1 + s/0.059853), unit step
V1 r 0 PWL(0 0 1u 1)
Be e 0 V=V(r)-V(y)
Bx1 0 x1 I=1*V(e)-V(x1)
Cx1 x1 0 16.7074802174
Bs2 s2 0 V=(0.0854795569506)*V(e)+(0.914520443049)*V(x1)
Bx3 0 x3 I=100*V(s2)
Cx3 x3 0 1
Rx3 x3 0 1e12
Bx4 0 x4 I=1*V(x3)-V(x4)
Cx4 x4 0 0.1
By y 0 V=V(x4)
.options reltol=1e-6 abstol=1e-12 vntol=1e-9
.tran 0.2m 10 0 0.2m
.end
