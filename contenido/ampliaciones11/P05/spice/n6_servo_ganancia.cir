* Position servo, P gain only K = 1.095367 (50 deg margin), unit step
V1 r 0 PWL(0 0 1u 1)
Be e 0 V=V(r)-V(y)
Bx1 0 x1 I=10.9536677531*V(e)
Cx1 x1 0 1
Rx1 x1 0 1e12
Bx2 0 x2 I=1*V(x1)-V(x2)
Cx2 x2 0 0.1
By y 0 V=V(x2)
.options reltol=1e-6 abstol=1e-12 vntol=1e-9
.tran 50u 2 0 50u
.end
